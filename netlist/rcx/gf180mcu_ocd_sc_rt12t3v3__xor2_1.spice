* NGSPICE file created from gf180mcu_ocd_sc_rt12t3v3__xor2_1.ext - technology: gf180mcuD

.subckt gf180mcu_ocd_sc_rt12t3v3__xor2_1 A B Y VDD VSS
X0 a_1317_987.t3 A.t2 VDD.t19 VDD.t18 pfet_03v3 ad=0.3341p pd=1.805u as=0.3341p ps=1.805u w=1.285u l=0.28u
X1 VDD.t15 A.t4 AN.t2 VDD.t14 pfet_03v3 ad=0.5654p pd=3.45u as=0.3341p ps=1.805u w=1.285u l=0.28u
X2 Y.t3 AN.t4 a_540_987.t0 VDD.t2 pfet_03v3 ad=0.3341p pd=1.805u as=0.5654p ps=3.45u w=1.285u l=0.28u
X3 a_830_145# AN Y VSS nfet_03v3 ad=0.52065p pd=3.23u as=0.3087p ps=2.01u w=1.02u l=0.28u
X4 a_540_987.t3 B.t4 VDD.t7 VDD.t6 pfet_03v3 ad=0.5654p pd=3.45u as=0.3341p ps=1.805u w=1.285u l=0.28u
X5 AN.t0 A.t1 VSS.t4 VSS.t0 nfet_03v3 ad=0.3087p pd=2.01u as=3.00385p ps=16.695u w=1.02u l=0.28u
X6 a_540_987.t1 AN.t3 Y.t4 VDD.t3 pfet_03v3 ad=0.3341p pd=1.805u as=0.3341p ps=1.805u w=1.285u l=0.28u
X7 Y.t1 BN.t5 a_1317_987.t0 VDD.t0 pfet_03v3 ad=0.3341p pd=1.805u as=0.3341p ps=1.805u w=1.285u l=0.28u
X8 BN.t0 B.t0 VSS.t3 VSS.t0 nfet_03v3 ad=0.3087p pd=2.01u as=4.00512p ps=22.26u w=1.02u l=0.28u
X9 BN.t1 B.t3 VDD.t9 VDD.t8 pfet_03v3 ad=0.3341p pd=1.805u as=0.5654p ps=3.45u w=1.285u l=0.28u
X10 a_1417_203r# A.t0 VSS.t5 VSS.t0 nfet_03v3 ad=0.3087p pd=2.015u as=3.00385p ps=16.695u w=1.02u l=0.28u
X11 a_1317_987.t1 BN.t4 Y.t2 VDD.t1 pfet_03v3 ad=0.5654p pd=3.45u as=0.3341p ps=1.805u w=1.285u l=0.28u
X12 Y.t0 B.t1 a_1417_203r# VSS.t2 nfet_03v3 ad=0.3087p pd=2.01u as=0.5148p ps=3.22u w=1.02u l=0.28u
X13 AN.t1 A.t5 VDD.t17 VDD.t16 pfet_03v3 ad=0.3341p pd=1.805u as=0.5654p ps=3.45u w=1.285u l=0.28u
X14 VDD.t5 B.t5 a_540_987.t2 VDD.t4 pfet_03v3 ad=0.3341p pd=1.805u as=0.3341p ps=1.805u w=1.285u l=0.28u
X15 VDD.t13 A.t3 a_1317_987.t2 VDD.t12 pfet_03v3 ad=0.3341p pd=1.805u as=0.5654p ps=3.45u w=1.285u l=0.28u
X16 a_830_145# BN.t3 VSS.t1 VSS.t0 nfet_03v3 ad=0.3087p pd=2.01u as=4.00512p ps=22.26u w=1.02u l=0.28u
X17 VDD.t11 B.t2 BN.t2 VDD.t10 pfet_03v3 ad=0.5654p pd=3.45u as=0.3341p ps=1.805u w=1.285u l=0.28u
R0 Y.n2 Y.t0 11.6272
R1 Y.n2 Y.n1 10.4265
R2 Y Y.n2 6.69423
R3 Y Y.n0 5.6355
R4 Y.n1 Y.t2 1.41684
R5 Y.n1 Y.t1 1.41684
R6 Y.n0 Y.t4 1.41684
R7 Y.n0 Y.t3 1.41684
R8 B.n1 B.t3 39.6951
R9 B.n1 B.t2 38.0951
R10 B.n2 B.t5 31.0545
R11 B.n2 B.t4 23.7545
R12 B.n0 B.t1 8.05982
R13 B.n0 B.n2 6.87854
R14 B B.n1 4.33762
R15 B B.t0 10.8414
R16 B B.n0 1.02233
R17 A.n0 A.t4 39.6951
R18 A.n0 A.t5 38.0951
R19 A.n1 A.t2 31.1559
R20 A.n1 A.t3 23.6531
R21 A.n2 A.n1 14.0696
R22 A A.n0 4.53147
R23 A A.n2 2.26686
R24 A.n2 A.t0 9.40349
R25 A A.t1 7.55542
R26 VDD.n68 VDD.n67 363.252
R27 VDD.n70 VDD.n69 137.088
R28 VDD.n41 VDD.n40 137.088
R29 VDD.n42 VDD.n39 137.088
R30 VDD.n46 VDD.n45 137.088
R31 VDD.n50 VDD.n35 137.088
R32 VDD.n52 VDD.n51 137.088
R33 VDD.n55 VDD.n31 137.088
R34 VDD.n57 VDD.n30 137.088
R35 VDD.n61 VDD.n60 137.088
R36 VDD.n62 VDD.n28 137.088
R37 VDD.n66 VDD.n24 137.088
R38 VDD.n60 VDD.t1 126.072
R39 VDD.n70 VDD.t16 117.504
R40 VDD.n39 VDD.t2 117.504
R41 VDD.n51 VDD.t6 117.504
R42 VDD.t10 VDD.n24 117.504
R43 VDD.n52 VDD.t12 108.936
R44 VDD.n56 VDD.t18 106.487
R45 VDD.n42 VDD.t14 97.9197
R46 VDD.n47 VDD.t3 97.9197
R47 VDD.n47 VDD.t4 97.9197
R48 VDD.t8 VDD.n61 97.9197
R49 VDD.t0 VDD.n56 89.3518
R50 VDD.n57 VDD.t0 47.7361
R51 VDD.t14 VDD.n41 39.1682
R52 VDD.t3 VDD.n46 39.1682
R53 VDD.t4 VDD.n35 39.1682
R54 VDD.n62 VDD.t8 39.1682
R55 VDD.t18 VDD.n55 30.6003
R56 VDD.t12 VDD.n31 28.1523
R57 VDD.n40 VDD.t16 19.5843
R58 VDD.n45 VDD.t2 19.5843
R59 VDD.t6 VDD.n50 19.5843
R60 VDD.n28 VDD.t10 19.5843
R61 VDD.n30 VDD.t1 11.0164
R62 VDD.n2 VDD.n23 5.514
R63 VDD.n72 VDD.n71 9.8005
R64 VDD.n71 VDD.n13 2.75725
R65 VDD.n38 VDD.n18 9.8005
R66 VDD.n43 VDD.n38 9.8005
R67 VDD.n7 VDD.n6 2.75725
R68 VDD.n44 VDD.n6 9.8005
R69 VDD.n8 VDD.n37 2.75725
R70 VDD.n48 VDD.n37 9.8005
R71 VDD.n48 VDD.n16 9.8005
R72 VDD.n14 VDD.n16 2.75725
R73 VDD.n49 VDD.n34 9.8005
R74 VDD.n4 VDD.n34 2.75725
R75 VDD.n53 VDD.n32 9.8005
R76 VDD.n15 VDD.n32 2.75725
R77 VDD.n54 VDD.n29 9.8005
R78 VDD.n58 VDD.n29 9.8005
R79 VDD.n10 VDD.n9 2.75725
R80 VDD.n59 VDD.n9 9.8005
R81 VDD.n11 VDD.n27 2.75725
R82 VDD.n63 VDD.n27 9.8005
R83 VDD.n63 VDD.n26 9.8005
R84 VDD.n12 VDD.n26 2.75725
R85 VDD.n65 VDD.n64 9.8005
R86 VDD.n21 VDD.n20 9.8005
R87 VDD.n3 VDD.n17 4.93411
R88 VDD.n5 VDD.n25 4.93411
R89 VDD VDD.n72 6.3005
R90 VDD.n71 VDD.n70 6.3005
R91 VDD.n13 VDD 1.77287
R92 VDD.n40 VDD.n18 6.3005
R93 VDD.n13 VDD.n18 2.75725
R94 VDD.n41 VDD.n38 6.3005
R95 VDD.n38 VDD 6.3005
R96 VDD.n43 VDD.n42 6.3005
R97 VDD.n7 VDD.n43 2.75725
R98 VDD.n39 VDD.n6 6.3005
R99 VDD VDD.n7 1.77287
R100 VDD.n45 VDD.n44 6.3005
R101 VDD.n44 VDD.n8 2.75725
R102 VDD.n46 VDD.n37 6.3005
R103 VDD.n8 VDD 1.77287
R104 VDD.n48 VDD.n47 6.3005
R105 VDD VDD.n48 6.3005
R106 VDD.n16 VDD.n35 6.3005
R107 VDD VDD.n14 1.77287
R108 VDD.n50 VDD.n49 6.3005
R109 VDD.n49 VDD.n14 2.75725
R110 VDD.n51 VDD.n34 6.3005
R111 VDD.n4 VDD 1.77287
R112 VDD.n53 VDD.n52 6.3005
R113 VDD.n4 VDD.n53 2.75725
R114 VDD.n32 VDD.n31 6.3005
R115 VDD VDD.n15 1.77287
R116 VDD.n55 VDD.n54 6.3005
R117 VDD.n54 VDD.n15 2.75725
R118 VDD.n56 VDD.n29 6.3005
R119 VDD.n29 VDD.n1 6.3005
R120 VDD.n58 VDD.n57 6.3005
R121 VDD.n10 VDD.n58 2.75725
R122 VDD.n30 VDD.n9 6.3005
R123 VDD.n60 VDD.n59 6.3005
R124 VDD.n59 VDD.n11 2.75725
R125 VDD.n61 VDD.n27 6.3005
R126 VDD.n11 VDD.n1 1.77287
R127 VDD.n63 VDD.n62 6.3005
R128 VDD.n1 VDD.n63 6.3005
R129 VDD.n28 VDD.n26 6.3005
R130 VDD.n1 VDD.n12 1.77287
R131 VDD.n64 VDD.n24 6.3005
R132 VDD.n64 VDD.n12 2.75725
R133 VDD.n66 VDD.n65 6.3005
R134 VDD.n65 VDD.n5 2.17736
R135 VDD.n67 VDD.n66 6.3005
R136 VDD.n2 VDD.n1 1.77287
R137 VDD.n5 VDD.n1 2.06282
R138 VDD.n3 VDD 1.77287
R139 VDD VDD.n21 6.3005
R140 VDD.n69 VDD.n20 6.3005
R141 VDD.n69 VDD.n68 6.3005
R142 VDD.n23 VDD.n0 5.4873
R143 VDD VDD.n33 5.42746
R144 VDD VDD.n36 5.42746
R145 VDD.n1 VDD.t11 4.32793
R146 VDD VDD.t17 4.32793
R147 VDD.n1 VDD.t9 4.32597
R148 VDD VDD.t15 4.32597
R149 VDD.n67 VDD.n0 2.82549
R150 VDD.n68 VDD.n22 2.82549
R151 VDD.n2 VDD.n25 5.514
R152 VDD.n21 VDD.n19 2.75725
R153 VDD.n3 VDD.n19 5.514
R154 VDD.n22 VDD.n20 2.73055
R155 VDD.n1 VDD.n10 2.64888
R156 VDD.n72 VDD.n17 2.17736
R157 VDD VDD.n1 2.1365
R158 VDD.n69 VDD.n17 2.06282
R159 VDD.n1 VDD.n0 2.03587
R160 VDD.n22 VDD 2.03587
R161 VDD.n66 VDD.n23 1.77287
R162 VDD.n66 VDD.n25 1.77287
R163 VDD.n69 VDD.n19 1.77287
R164 VDD.n33 VDD.t13 1.41684
R165 VDD.n33 VDD.t19 1.41684
R166 VDD.n36 VDD.t5 1.41684
R167 VDD.n36 VDD.t7 1.41684
R168 VSS.n37 VSS.n35 129.143
R169 VSS.n50 VSS.n25 129.078
R170 VSS.n40 VSS.n35 129.078
R171 VSS.t2 VSS.n25 70.3019
R172 VSS.n40 VSS.t0 56.4721
R173 VSS.n2 VSS.n26 5.32092
R174 VSS.n43 VSS.n1 10.8894
R175 VSS.n44 VSS.n1 10.8894
R176 VSS.n28 VSS.n13 5.28505
R177 VSS.n52 VSS.n24 10.8894
R178 VSS.n39 VSS.n11 10.8894
R179 VSS.n39 VSS.n36 10.8894
R180 VSS.n41 VSS.n32 10.8894
R181 VSS.n41 VSS.n34 10.8894
R182 VSS.n47 VSS.n23 10.5415
R183 VSS.n22 VSS.n3 2.50574
R184 VSS.n21 VSS.n17 2.4988
R185 VSS.n15 VSS.n14 7.92821
R186 VSS.n19 VSS.n28 5.15789
R187 VSS.n9 VSS.n8 7.92821
R188 VSS.n38 VSS.n37 7.81835
R189 VSS.n37 VSS.n33 7.81835
R190 VSS.n5 VSS.n23 2.4771
R191 VSS.n11 VSS.n24 7.38939
R192 VSS.n49 VSS.n10 4.82111
R193 VSS VSS.n52 5.2005
R194 VSS.n50 VSS.n24 5.2005
R195 VSS.n24 VSS 5.2005
R196 VSS VSS.n7 1.6297
R197 VSS.n8 VSS 5.2005
R198 VSS VSS.n13 1.27115
R199 VSS.n29 VSS.n13 5.32092
R200 VSS VSS.n44 5.2005
R201 VSS.n50 VSS.n1 5.2005
R202 VSS VSS.n1 5.2005
R203 VSS VSS.n43 5.2005
R204 VSS.n50 VSS.n17 5.2005
R205 VSS VSS.n21 1.3521
R206 VSS.n19 VSS 1.00728
R207 VSS.n22 VSS.n27 5.16594
R208 VSS.n50 VSS.n23 5.2005
R209 VSS VSS.n5 1.02858
R210 VSS.n50 VSS.n3 5.2005
R211 VSS VSS.n22 1.34863
R212 VSS.n2 VSS.n31 5.159
R213 VSS.n2 VSS.n0 1.27115
R214 VSS.n0 VSS.n12 1.27115
R215 VSS.n0 VSS.n47 5.2005
R216 VSS.n50 VSS.n14 5.2005
R217 VSS.n20 VSS.n14 2.62485
R218 VSS.n16 VSS.n0 1.63997
R219 VSS.n10 VSS.n0 1.52105
R220 VSS.n0 VSS.n20 1.28908
R221 VSS.n35 VSS.n34 5.2005
R222 VSS.n41 VSS.n40 5.2005
R223 VSS.n0 VSS.n41 5.2005
R224 VSS.n32 VSS.n25 5.2005
R225 VSS.n10 VSS.n32 2.1609
R226 VSS.n11 VSS.n25 5.2005
R227 VSS VSS.n11 5.2005
R228 VSS.n40 VSS.n39 5.2005
R229 VSS.n39 VSS 5.2005
R230 VSS.n36 VSS.n35 5.2005
R231 VSS.n15 VSS.t3 4.5995
R232 VSS.n4 VSS.n46 4.5995
R233 VSS.n18 VSS.t1 4.5995
R234 VSS.n9 VSS.n42 4.5995
R235 VSS.n15 VSS.n48 4.4735
R236 VSS.n18 VSS.n45 4.4735
R237 VSS.n4 VSS.t5 4.4105
R238 VSS.n9 VSS.t4 4.4105
R239 VSS.n9 VSS.n7 0.535676
R240 VSS.n19 VSS.n18 1.53514
R241 VSS.n5 VSS.n4 1.50094
R242 VSS.n16 VSS.n15 0.51919
R243 VSS.n47 VSS.n30 2.66071
R244 VSS.n49 VSS.n20 5.28505
R245 VSS.n12 VSS.n30 5.32092
R246 VSS.n12 VSS.n26 5.32092
R247 VSS.n21 VSS.n27 5.159
R248 VSS.n44 VSS.n29 2.66071
R249 VSS.n34 VSS.n33 2.63361
R250 VSS.n38 VSS.n36 2.63361
R251 VSS.n52 VSS.n51 2.62485
R252 VSS.n51 VSS.n8 2.62485
R253 VSS.n43 VSS.n6 2.4988
R254 VSS.n7 VSS.n6 3.38194
R255 VSS.t0 VSS.t2 2.30546
R256 VSS.n0 VSS 1.7795
R257 VSS.n18 VSS.n17 1.64457
R258 VSS.n16 VSS.n31 3.35472
R259 VSS.n4 VSS.n3 2.04492
R260 VSS VSS.n38 1.53032
R261 VSS.n0 VSS.n33 1.53032
R262 VSS.n50 VSS.n6 1.3521
R263 VSS.n50 VSS.n31 1.3521
R264 VSS.n51 VSS.n50 1.28908
R265 VSS.n50 VSS.n28 1.28908
R266 VSS.n50 VSS.n29 1.27115
R267 VSS.n50 VSS.n27 1.27115
R268 VSS.n50 VSS.n26 1.27115
R269 VSS.n50 VSS.n30 1.27115
R270 VSS.n50 VSS.n49 1.27115
R271 VSS.n0 VSS 1.09372
R272 VSS.n0 VSS 1.06669
R273 a_1317_987.n0 a_1317_987.t2 4.91293
R274 a_1317_987.n0 a_1317_987.t1 4.89923
R275 a_1317_987.n1 a_1317_987.n0 2.6005
R276 a_1317_987.t0 a_1317_987.n1 1.41684
R277 a_1317_987.n1 a_1317_987.t3 1.41684
R278 a_540_987.n1 a_540_987.t3 4.91293
R279 a_540_987.t0 a_540_987.n1 4.89923
R280 a_540_987.n1 a_540_987.n0 2.6005
R281 a_540_987.n0 a_540_987.t2 1.41684
R282 a_540_987.n0 a_540_987.t1 1.41684
R283 BN.n1 BN.t5 41.4913
R284 BN.n1 BN.t4 19.4862
R285 BN.n0 BN.n1 13.0969
R286 BN.t0 BN.n3 3.32853
R287 BN.n0 BN.n2 2.90767
R288 BN.n0 BN.t3 18.9144
R289 BN.n2 BN.t1 1.41684
R290 BN.n2 BN.t2 1.41684
R291 BN BN.t0 7.80377
R292 BN BN.n0 1.61933
R293 AN.n0 AN.t3 41.5588
R294 AN.n0 AN.t4 19.4766
R295 AN.n2 AN.n0 12.5488
R296 AN.t0 AN.n3 3.32853
R297 AN.n2 AN.n1 2.90767
R298 AN.n1 AN.t1 1.41684
R299 AN.n1 AN.t2 1.41684
R300 AN AN.t0 7.80377
R301 AN AN.n2 1.04415
C0 A AN 1.36445f
C1 A Y 1.23106f
C2 BN Y 0.25548f
C3 A BN 0.89493f
C4 Y a_1417_203r# 0.22936f
C5 VDD AN 1.05311f
C6 A a_1417_203r# 0.13104f
C7 VDD Y 0.2193f
C8 A VDD 0.76381f
C9 VDD BN 1.15734f
C10 Y B 1.08706f
C11 BN B 1.63467f
C12 VDD B 0.89537f
C13 Y AN 0.39854f
C14 BN a_830_145# 0.13273f
C15 Y VSS 2.25642f
C16 B VSS 1.83172f
C17 A VSS 2.03965f
C18 VDD VSS 7.90325f
C19 a_1417_203r# VSS 0.11146f
C20 a_830_145# VSS 0.10938f
C21 BN VSS 1.33805f
C22 AN VSS 2.27813f
C23 AN.t0 VSS 0.33142f
C24 AN.t3 VSS 0.12091f
C25 AN.n0 VSS 0.17322f
C26 AN.n1 VSS 0.12889f
C27 AN.n2 VSS 0.47401f
C28 AN.n3 VSS 0.22393f
C29 BN.n0 VSS 1.36565f
C30 BN.t0 VSS 0.27748f
C31 BN.t3 VSS 1.12219f
C32 BN.t5 VSS 0.15199f
C33 BN.t4 VSS 0.10157f
C34 BN.n1 VSS 0.20623f
C35 BN.n2 VSS 0.16219f
C36 BN.n3 VSS 0.2818f
C37 a_540_987.t3 VSS 0.26151f
C38 a_540_987.n0 VSS 0.16574f
C39 a_540_987.n1 VSS 0.73897f
C40 a_540_987.t0 VSS 0.26047f
C41 a_1317_987.t1 VSS 0.27511f
C42 a_1317_987.t2 VSS 0.27622f
C43 a_1317_987.n0 VSS 0.78052f
C44 a_1317_987.n1 VSS 0.17506f
C45 VDD.n1 VSS 0.31276f
C46 VDD.n24 VSS 0.15218f
C47 VDD.n35 VSS 0.10536f
C48 VDD.n39 VSS 0.15218f
C49 VDD.n41 VSS 0.10536f
C50 VDD.n42 VSS 0.14048f
C51 VDD.n46 VSS 0.10536f
C52 VDD.n47 VSS 0.11707f
C53 VDD.n51 VSS 0.15218f
C54 VDD.n52 VSS 0.14706f
C55 VDD.n55 VSS 0.10024f
C56 VDD.n56 VSS 0.11706f
C57 VDD.n57 VSS 0.11048f
C58 VDD.n60 VSS 0.15731f
C59 VDD.n61 VSS 0.14048f
C60 VDD.n62 VSS 0.10536f
C61 VDD.n66 VSS 0.24584f
C62 VDD.n67 VSS 0.11246f
C63 VDD.n68 VSS 0.11246f
C64 VDD.n69 VSS 0.2751f
C65 VDD.n70 VSS 0.15218f
C66 A.t4 VSS 0.15127f
C67 A.t5 VSS 0.14428f
C68 A.n0 VSS 0.27122f
C69 A.t1 VSS 0.80825f
C70 A.t2 VSS 0.13856f
C71 A.t3 VSS 0.11717f
C72 A.n1 VSS 0.44273f
C73 A.t0 VSS 0.58245f
C74 A.n2 VSS 1.08241f
C75 B.n0 VSS 1.01279f
C76 B.t2 VSS 0.12321f
C77 B.t3 VSS 0.12919f
C78 B.n1 VSS 0.22493f
C79 B.t4 VSS 0.10047f
C80 B.t5 VSS 0.11801f
C81 B.n2 VSS 0.35471f
C82 B.t1 VSS 0.54378f
C83 B.t0 VSS 0.54408f
C84 Y.n0 VSS 0.1707f
C85 Y.n1 VSS 0.25343f
C86 Y.t0 VSS 0.43993f
C87 Y.n2 VSS 0.94422f
.ends
