* NGSPICE file created from gf180mcu_ocd_sc_rt12t3v3__xor2_1.ext - technology: gf180mcuD

.subckt gf180mcu_ocd_sc_rt12t3v3__xor2_1 A B Y VDD VSS
X0 a_1317_987.t2 A.t2 VDD.t8 VDD.t7 pfet_03v3 ad=0.3341p pd=1.805u as=0.3341p ps=1.805u w=1.285u l=0.28u
X1 VDD.t6 A.t4 AN.t1 VDD.t5 pfet_03v3 ad=0.5654p pd=3.45u as=0.3341p ps=1.805u w=1.285u l=0.28u
X2 Y.t1 AN.t4 a_540_987.t0 VDD.t0 pfet_03v3 ad=0.3341p pd=1.805u as=0.5654p ps=3.45u w=1.285u l=0.28u
X3 a_830_145# AN Y VSS.t4 nfet_03v3 ad=0.52065p pd=3.23u as=0.3087p ps=2.01u w=1.02u l=0.28u
X4 a_540_987.t3 B.t4 VDD.t15 VDD.t14 pfet_03v3 ad=0.5654p pd=3.45u as=0.3341p ps=1.805u w=1.285u l=0.28u
X5 AN.t2 A.t1 VSS.t3 VSS.t0 nfet_03v3 ad=0.3087p pd=2.01u as=3.00385p ps=16.695u w=1.02u l=0.28u
X6 a_540_987.t1 AN.t3 Y.t3 VDD.t2 pfet_03v3 ad=0.3341p pd=1.805u as=0.3341p ps=1.805u w=1.285u l=0.28u
X7 Y.t4 BN.t5 a_1317_987.t3 VDD.t11 pfet_03v3 ad=0.3341p pd=1.805u as=0.3341p ps=1.805u w=1.285u l=0.28u
X8 BN.t2 B.t0 VSS.t6 VSS.t0 nfet_03v3 ad=0.3087p pd=2.01u as=4.00512p ps=22.26u w=1.02u l=0.28u
X9 BN.t0 B.t3 VDD.t17 VDD.t16 pfet_03v3 ad=0.3341p pd=1.805u as=0.5654p ps=3.45u w=1.285u l=0.28u
X10 a_1417_203r# A.t0 VSS.t2 VSS.t0 nfet_03v3 ad=0.3087p pd=2.015u as=3.00385p ps=16.695u w=1.02u l=0.28u
X11 a_1317_987.t0 BN.t4 Y.t2 VDD.t1 pfet_03v3 ad=0.5654p pd=3.45u as=0.3341p ps=1.805u w=1.285u l=0.28u
X12 Y.t0 B.t1 a_1417_203r# VSS.t5 nfet_03v3 ad=0.3087p pd=2.01u as=0.5148p ps=3.22u w=1.02u l=0.28u
X13 AN.t0 A.t5 VDD.t4 VDD.t3 pfet_03v3 ad=0.3341p pd=1.805u as=0.5654p ps=3.45u w=1.285u l=0.28u
X14 VDD.t13 B.t5 a_540_987.t2 VDD.t12 pfet_03v3 ad=0.3341p pd=1.805u as=0.3341p ps=1.805u w=1.285u l=0.28u
X15 VDD.t10 A.t3 a_1317_987.t1 VDD.t9 pfet_03v3 ad=0.3341p pd=1.805u as=0.5654p ps=3.45u w=1.285u l=0.28u
X16 a_830_145# BN.t3 VSS.t1 VSS.t0 nfet_03v3 ad=0.3087p pd=2.01u as=4.00512p ps=22.26u w=1.02u l=0.28u
X17 VDD.t19 B.t2 BN.t1 VDD.t18 pfet_03v3 ad=0.5654p pd=3.45u as=0.3341p ps=1.805u w=1.285u l=0.28u
R0 Y.t0 Y.n4 1.68642
R1 Y.t0 Y.n0 0.152381
R2 Y.n1 Y.n3 1.68642
R3 Y.n1 Y.n2 0.152381
R4 Y.n9 Y.n8 85.0505
R5 Y.n23 Y.n18 85.0505
R6 Y.n12 Y.n9 47.2505
R7 Y.n14 Y.n11 23.1801
R8 Y.n22 Y.n19 18.4257
R9 Y.n13 Y.n5 16.9456
R10 Y Y.n25 16.1343
R11 Y.n1 Y.n20 14.7309
R12 Y.n21 Y.n19 13.736
R13 Y.n17 Y.n16 11.5308
R14 Y.n12 Y.n10 10.4505
R15 Y.n17 Y.n7 10.4265
R16 Y.n5 Y.n10 8.32713
R17 Y Y.n17 6.5407
R18 Y.n14 Y.n10 5.73172
R19 Y.n21 Y.n20 5.4755
R20 Y.n13 Y.n0 5.38578
R21 Y.n2 Y.n21 5.38578
R22 Y.n24 Y.n19 3.6505
R23 Y.n15 Y.n14 3.1505
R24 Y.n15 Y.n9 3.1505
R25 Y.t0 Y.n12 3.1505
R26 Y.n24 Y.n23 3.1505
R27 Y.n16 Y.t0 2.93326
R28 Y.n25 Y.n1 2.93326
R29 Y.n23 Y.n22 2.86474
R30 Y.t0 Y.n5 2.1221
R31 Y.n11 Y.n13 1.92498
R32 Y.n0 Y.n8 3.86742
R33 Y.n15 Y.n4 0.0332878
R34 Y.n8 Y.n4 48.9364
R35 Y.n2 Y.n18 3.86742
R36 Y.n24 Y.n3 0.0332878
R37 Y.n18 Y.n3 48.9364
R38 Y Y.n6 5.6355
R39 Y.n22 Y.n1 1.71736
R40 Y.n16 Y.n8 1.62981
R41 Y.n25 Y.n18 1.62981
R42 Y.n6 Y.t1 1.41684
R43 Y.n6 Y.t3 1.41684
R44 Y.n7 Y.t4 1.41684
R45 Y.n7 Y.t2 1.41684
R46 B.n1 B.t3 39.6951
R47 B.n1 B.t2 38.0951
R48 B.n2 B.t5 31.0545
R49 B.n2 B.t4 23.7545
R50 B.n0 B.t1 8.34599
R51 B.n0 B.n2 6.87854
R52 B B.n1 4.33762
R53 B B.t0 8.1125
R54 B B.n0 1.02233
R55 A.n1 A.n0 2.50334
R56 A.n9 A.n8 124.1
R57 A.n2 A.t4 39.6951
R58 A.n2 A.t5 38.0951
R59 A.n3 A.t2 31.1559
R60 A.n11 A.n8 29.2005
R61 A.n7 A.n6 27.8461
R62 A.n3 A.t3 23.6531
R63 A.n16 A.n3 14.0696
R64 A.n13 A.n12 11.5588
R65 A.n12 A.n7 9.96489
R66 A.n14 A.n13 8.6736
R67 A.n13 A.n5 8.16955
R68 A.n10 A.n7 5.60586
R69 A.n8 A.n5 4.86717
R70 A A.t1 7.94065
R71 A A.n2 4.53147
R72 A.n6 A.n0 13.5619
R73 A.n14 A.n4 3.97515
R74 A.n9 A.n4 3.6505
R75 A.n10 A.n9 3.6505
R76 A.n12 A.n11 3.33676
R77 A.n15 A.n14 3.2125
R78 A.n14 A.n0 6.02051
R79 A.n15 A.n1 2.69287
R80 A.n16 A.n15 2.66717
R81 A.t0 A.n1 2.39646
R82 A A.n16 2.26686
R83 A.n11 A.n10 1.95586
R84 A.n5 A.n4 1.8255
R85 A.n6 A.t0 1.11195
R86 VDD.n68 VDD.n67 363.252
R87 VDD.n70 VDD.n69 137.088
R88 VDD.n41 VDD.n40 137.088
R89 VDD.n42 VDD.n39 137.088
R90 VDD.n46 VDD.n45 137.088
R91 VDD.n50 VDD.n35 137.088
R92 VDD.n52 VDD.n51 137.088
R93 VDD.n55 VDD.n31 137.088
R94 VDD.n57 VDD.n30 137.088
R95 VDD.n61 VDD.n60 137.088
R96 VDD.n62 VDD.n28 137.088
R97 VDD.n66 VDD.n24 137.088
R98 VDD.n60 VDD.t1 126.072
R99 VDD.n70 VDD.t3 117.504
R100 VDD.n39 VDD.t0 117.504
R101 VDD.n51 VDD.t14 117.504
R102 VDD.t18 VDD.n24 117.504
R103 VDD.n52 VDD.t9 108.936
R104 VDD.n56 VDD.t7 106.487
R105 VDD.n42 VDD.t5 97.9197
R106 VDD.n47 VDD.t2 97.9197
R107 VDD.n47 VDD.t12 97.9197
R108 VDD.t16 VDD.n61 97.9197
R109 VDD.t11 VDD.n56 89.3518
R110 VDD.n57 VDD.t11 47.7361
R111 VDD.t5 VDD.n41 39.1682
R112 VDD.t2 VDD.n46 39.1682
R113 VDD.t12 VDD.n35 39.1682
R114 VDD.n62 VDD.t16 39.1682
R115 VDD.t7 VDD.n55 30.6003
R116 VDD.t9 VDD.n31 28.1523
R117 VDD.n40 VDD.t3 19.5843
R118 VDD.n45 VDD.t0 19.5843
R119 VDD.t14 VDD.n50 19.5843
R120 VDD.n28 VDD.t18 19.5843
R121 VDD.n30 VDD.t1 11.0164
R122 VDD.n72 VDD.n71 9.8005
R123 VDD.n71 VDD.n13 2.75725
R124 VDD.n38 VDD.n18 9.8005
R125 VDD.n43 VDD.n38 9.8005
R126 VDD.n7 VDD.n6 2.75725
R127 VDD.n44 VDD.n6 9.8005
R128 VDD.n8 VDD.n37 2.75725
R129 VDD.n48 VDD.n37 9.8005
R130 VDD.n48 VDD.n16 9.8005
R131 VDD.n14 VDD.n16 2.75725
R132 VDD.n49 VDD.n34 9.8005
R133 VDD.n4 VDD.n34 2.75725
R134 VDD.n53 VDD.n32 9.8005
R135 VDD.n15 VDD.n32 2.75725
R136 VDD.n54 VDD.n29 9.8005
R137 VDD.n58 VDD.n29 9.8005
R138 VDD.n10 VDD.n9 2.75725
R139 VDD.n59 VDD.n9 9.8005
R140 VDD.n11 VDD.n27 2.75725
R141 VDD.n63 VDD.n27 9.8005
R142 VDD.n63 VDD.n26 9.8005
R143 VDD.n12 VDD.n26 2.75725
R144 VDD.n65 VDD.n64 9.8005
R145 VDD.n21 VDD.n20 9.8005
R146 VDD.n3 VDD.n17 4.93411
R147 VDD.n5 VDD.n25 4.93411
R148 VDD VDD.n72 6.3005
R149 VDD.n71 VDD.n70 6.3005
R150 VDD.n13 VDD 1.77287
R151 VDD.n40 VDD.n18 6.3005
R152 VDD.n13 VDD.n18 2.75725
R153 VDD.n41 VDD.n38 6.3005
R154 VDD.n38 VDD 6.3005
R155 VDD.n43 VDD.n42 6.3005
R156 VDD.n7 VDD.n43 2.75725
R157 VDD.n39 VDD.n6 6.3005
R158 VDD VDD.n7 1.77287
R159 VDD.n45 VDD.n44 6.3005
R160 VDD.n44 VDD.n8 2.75725
R161 VDD.n46 VDD.n37 6.3005
R162 VDD.n8 VDD 1.77287
R163 VDD.n48 VDD.n47 6.3005
R164 VDD VDD.n48 6.3005
R165 VDD.n16 VDD.n35 6.3005
R166 VDD VDD.n14 1.77287
R167 VDD.n50 VDD.n49 6.3005
R168 VDD.n49 VDD.n14 2.75725
R169 VDD.n51 VDD.n34 6.3005
R170 VDD.n4 VDD 1.77287
R171 VDD.n53 VDD.n52 6.3005
R172 VDD.n4 VDD.n53 2.75725
R173 VDD.n32 VDD.n31 6.3005
R174 VDD VDD.n15 1.77287
R175 VDD.n55 VDD.n54 6.3005
R176 VDD.n54 VDD.n15 2.75725
R177 VDD.n56 VDD.n29 6.3005
R178 VDD.n29 VDD.n1 6.3005
R179 VDD.n58 VDD.n57 6.3005
R180 VDD.n10 VDD.n58 2.75725
R181 VDD.n30 VDD.n9 6.3005
R182 VDD.n60 VDD.n59 6.3005
R183 VDD.n59 VDD.n11 2.75725
R184 VDD.n61 VDD.n27 6.3005
R185 VDD.n11 VDD.n1 1.77287
R186 VDD.n63 VDD.n62 6.3005
R187 VDD.n1 VDD.n63 6.3005
R188 VDD.n28 VDD.n26 6.3005
R189 VDD.n1 VDD.n12 1.77287
R190 VDD.n64 VDD.n24 6.3005
R191 VDD.n64 VDD.n12 2.75725
R192 VDD.n66 VDD.n65 6.3005
R193 VDD.n65 VDD.n5 2.17736
R194 VDD.n67 VDD.n66 6.3005
R195 VDD.n1 VDD.n2 1.77287
R196 VDD.n5 VDD.n1 2.06282
R197 VDD.n3 VDD 1.77287
R198 VDD VDD.n21 6.3005
R199 VDD.n69 VDD.n20 6.3005
R200 VDD.n69 VDD.n68 6.3005
R201 VDD.n23 VDD.n0 5.4873
R202 VDD VDD.n33 5.42746
R203 VDD VDD.n36 5.42746
R204 VDD.n1 VDD.t19 4.32793
R205 VDD VDD.t4 4.32793
R206 VDD.n1 VDD.t17 4.32597
R207 VDD VDD.t6 4.32597
R208 VDD.n67 VDD.n0 2.82549
R209 VDD.n68 VDD.n22 2.82549
R210 VDD.n2 VDD.n23 5.514
R211 VDD.n2 VDD.n25 5.514
R212 VDD.n21 VDD.n19 2.75725
R213 VDD.n3 VDD.n19 5.514
R214 VDD.n22 VDD.n20 2.73055
R215 VDD.n1 VDD.n10 2.64888
R216 VDD.n72 VDD.n17 2.17736
R217 VDD VDD.n1 2.1365
R218 VDD.n69 VDD.n17 2.06282
R219 VDD.n1 VDD.n0 2.03587
R220 VDD.n22 VDD 2.03587
R221 VDD.n66 VDD.n23 1.77287
R222 VDD.n66 VDD.n25 1.77287
R223 VDD.n69 VDD.n19 1.77287
R224 VDD.n33 VDD.t10 1.41684
R225 VDD.n33 VDD.t8 1.41684
R226 VDD.n36 VDD.t13 1.41684
R227 VDD.n36 VDD.t15 1.41684
R228 VSS.n36 VSS.n33 129.143
R229 VSS.n52 VSS.n24 129.078
R230 VSS.n39 VSS.n33 129.078
R231 VSS.t5 VSS.n24 70.3019
R232 VSS.n39 VSS.t0 56.4721
R233 VSS.n12 VSS.n11 5.28505
R234 VSS.n51 VSS.n21 2.66071
R235 VSS.n51 VSS.n22 10.8894
R236 VSS.n2 VSS.n15 5.159
R237 VSS.n47 VSS.n46 10.8894
R238 VSS.n19 VSS.n18 2.66071
R239 VSS.n48 VSS.n18 10.8894
R240 VSS.n54 VSS.n23 10.8894
R241 VSS.n38 VSS.n9 10.8894
R242 VSS.n38 VSS.n34 10.8894
R243 VSS.n41 VSS.n1 2.66071
R244 VSS.n40 VSS.n32 10.8894
R245 VSS.n17 VSS.n49 7.92821
R246 VSS.n8 VSS.n7 7.92821
R247 VSS.n37 VSS.n36 7.81835
R248 VSS.n36 VSS.n35 7.81835
R249 VSS.n26 VSS.n3 5.0951
R250 VSS.n9 VSS.n23 7.38939
R251 VSS.n41 VSS.n10 7.38939
R252 VSS VSS.n54 5.2005
R253 VSS.n52 VSS.n23 5.2005
R254 VSS.n23 VSS 5.2005
R255 VSS VSS.n6 1.6297
R256 VSS.n7 VSS 5.2005
R257 VSS VSS.n48 5.2005
R258 VSS.n52 VSS.n18 5.2005
R259 VSS VSS.n19 1.27115
R260 VSS.n19 VSS.n28 5.32092
R261 VSS VSS.n47 5.2005
R262 VSS.n46 VSS 5.2005
R263 VSS VSS.n16 1.63997
R264 VSS.n49 VSS 5.2005
R265 VSS.n2 VSS.n27 5.16594
R266 VSS.n2 VSS 1.27115
R267 VSS VSS.n3 1.02858
R268 VSS.n50 VSS 5.2005
R269 VSS.n0 VSS.n22 5.2005
R270 VSS.n52 VSS.n51 5.2005
R271 VSS.n21 VSS.n0 1.27115
R272 VSS.n21 VSS.n30 5.32092
R273 VSS.n0 VSS.n20 1.27115
R274 VSS.n13 VSS.n0 1.00728
R275 VSS.n0 VSS.n42 5.2005
R276 VSS.n52 VSS.n10 5.2005
R277 VSS.n11 VSS.n10 2.66071
R278 VSS.n0 VSS.n11 1.27115
R279 VSS.n33 VSS.n32 5.2005
R280 VSS.n40 VSS.n39 5.2005
R281 VSS.n40 VSS.n1 2.66071
R282 VSS.n41 VSS.n24 5.2005
R283 VSS.n0 VSS.n1 1.27115
R284 VSS.n9 VSS.n24 5.2005
R285 VSS VSS.n9 5.2005
R286 VSS.n39 VSS.n38 5.2005
R287 VSS.n38 VSS 5.2005
R288 VSS.n34 VSS.n33 5.2005
R289 VSS.n14 VSS.t6 4.5995
R290 VSS.n17 VSS.t1 4.5995
R291 VSS.n4 VSS.t2 4.4105
R292 VSS.n8 VSS.t3 4.4105
R293 VSS.n8 VSS.n6 0.535676
R294 VSS.n17 VSS.n16 0.51919
R295 VSS.n4 VSS.n3 1.50094
R296 VSS.n14 VSS.n13 1.53514
R297 VSS.n4 VSS.n43 2.7725
R298 VSS.n8 VSS.n45 2.7725
R299 VSS.n20 VSS.n30 5.32092
R300 VSS.n47 VSS.n28 2.66071
R301 VSS.n14 VSS.n31 2.6465
R302 VSS.n17 VSS.n44 2.6465
R303 VSS.n35 VSS.n32 2.63361
R304 VSS.n37 VSS.n34 2.63361
R305 VSS.n54 VSS.n53 2.62485
R306 VSS.n49 VSS.n29 2.62485
R307 VSS.n13 VSS.n12 5.15789
R308 VSS.n48 VSS.n29 2.62485
R309 VSS.n53 VSS.n7 2.62485
R310 VSS.n20 VSS.n26 5.27871
R311 VSS.n50 VSS.n27 2.50574
R312 VSS.n46 VSS.n5 2.4988
R313 VSS.n42 VSS.n25 2.4988
R314 VSS.n22 VSS.n25 2.4988
R315 VSS.n16 VSS.n15 3.35472
R316 VSS.n6 VSS.n5 3.38194
R317 VSS.n4 VSS.n50 2.04492
R318 VSS.n0 VSS 1.7795
R319 VSS.n42 VSS.n14 1.64457
R320 VSS VSS.n37 1.53032
R321 VSS.n35 VSS.n0 1.53032
R322 VSS.n52 VSS.n5 1.3521
R323 VSS.n52 VSS.n15 1.3521
R324 VSS.n52 VSS.n25 1.3521
R325 VSS.n52 VSS.n27 1.34863
R326 VSS.n52 VSS.n26 1.29225
R327 VSS.n53 VSS.n52 1.28908
R328 VSS.n52 VSS.n29 1.28908
R329 VSS.n52 VSS.n12 1.28908
R330 VSS.n52 VSS.n28 1.27115
R331 VSS.n52 VSS.n30 1.27115
R332 VSS.t4 VSS.t5 1.15298
R333 VSS.t0 VSS.t4 1.15298
R334 VSS.n0 VSS 1.09372
R335 VSS.n0 VSS 1.06669
R336 a_1317_987.n0 a_1317_987.t1 4.91293
R337 a_1317_987.n0 a_1317_987.t0 4.89923
R338 a_1317_987.n1 a_1317_987.n0 2.6005
R339 a_1317_987.n1 a_1317_987.t3 1.41684
R340 a_1317_987.t2 a_1317_987.n1 1.41684
R341 a_540_987.n0 a_540_987.t3 4.91293
R342 a_540_987.n0 a_540_987.t0 4.89923
R343 a_540_987.n1 a_540_987.n0 2.6005
R344 a_540_987.t2 a_540_987.n1 1.41684
R345 a_540_987.n1 a_540_987.t1 1.41684
R346 BN.n8 BN.t2 50.9005
R347 BN.n6 BN.t5 41.4913
R348 BN.n2 BN.n9 32.5888
R349 BN.n6 BN.t4 19.4862
R350 BN.n9 BN.n8 16.9387
R351 BN.n3 BN.n6 13.0969
R352 BN.n8 BN.n0 11.9058
R353 BN BN.n4 7.10132
R354 BN.n4 BN.n0 3.31861
R355 BN.n9 BN.n5 3.6505
R356 BN.t3 BN.n3 18.3995
R357 BN.n3 BN.n7 2.90767
R358 BN.n2 BN.n0 0.0474974
R359 BN.n1 BN.t2 0.459182
R360 BN.n1 BN.n5 0.825727
R361 BN.n7 BN.t0 1.41684
R362 BN.n7 BN.t1 1.41684
R363 BN.n4 BN.t2 5.88322
R364 BN.n4 BN.n5 1.7588
R365 BN BN.n3 1.61933
R366 BN.n2 BN.n1 1.57306
R367 AN.n9 AN.t2 50.9005
R368 AN.n5 AN.t3 41.5588
R369 AN.n2 AN.n10 32.5888
R370 AN.n5 AN.t4 19.4766
R371 AN.n10 AN.n9 16.9387
R372 AN.n7 AN.n5 12.5488
R373 AN AN.n8 10.8293
R374 AN.n9 AN.n0 11.9058
R375 AN AN.n3 6.3005
R376 AN.n3 AN.n0 3.31861
R377 AN.n10 AN.n4 3.6505
R378 AN.n7 AN.n6 2.90767
R379 AN.n2 AN.n0 0.0474974
R380 AN.n1 AN.t2 0.459182
R381 AN.n1 AN.n4 0.825727
R382 AN.n6 AN.t0 1.41684
R383 AN.n6 AN.t1 1.41684
R384 AN.n3 AN.t2 5.88322
R385 AN AN.n7 1.84497
R386 AN.n3 AN.n4 1.7588
R387 AN.n2 AN.n1 1.57306
C0 A AN 1.36445f
C1 AN VDD 1.05311f
C2 A BN 0.89493f
C3 AN Y 0.39854f
C4 VDD BN 1.15734f
C5 BN Y 0.25548f
C6 B BN 1.63467f
C7 a_830_145# BN 0.13273f
C8 A VDD 0.76381f
C9 A Y 1.23106f
C10 VDD Y 0.2193f
C11 A a_1417_203r# 0.13104f
C12 a_1417_203r# Y 0.22936f
C13 B VDD 0.89537f
C14 B Y 1.08706f
C15 Y VSS 2.56183f
C16 B VSS 1.71325f
C17 A VSS 2.0356f
C18 VDD VSS 7.90325f
C19 a_1417_203r# VSS 0.40138f
C20 a_830_145# VSS 1.55018f
C21 BN VSS 1.31185f
C22 AN.n2 VSS 0.10566f
C23 AN.t2 VSS 0.38429f
C24 AN.n5 VSS 0.16564f
C25 AN.t1 VSS 0.15427f
C26 AN.t0 VSS 0.15249f
C27 AN.n6 VSS 0.12324f
C28 AN.n7 VSS 0.45327f
C29 AN.n8 VSS 0.55981f
C30 AN.n10 VSS 0.14377f
C31 BN.n2 VSS 0.13265f
C32 BN.n3 VSS 1.2986f
C33 BN.t2 VSS 0.32986f
C34 BN.n6 VSS 0.19673f
C35 BN.t1 VSS 0.15371f
C36 BN.t0 VSS 0.15524f
C37 BN.n7 VSS 0.15472f
C38 BN.n8 VSS 0.12295f
C39 BN.n9 VSS 0.18049f
C40 a_540_987.t1 VSS 0.16191f
C41 a_540_987.t0 VSS 0.32028f
C42 a_540_987.t3 VSS 0.33082f
C43 a_540_987.n0 VSS 0.73897f
C44 a_540_987.n1 VSS 0.16574f
C45 a_540_987.t2 VSS 0.16052f
C46 a_1317_987.t3 VSS 0.18668f
C47 a_1317_987.t0 VSS 0.35021f
C48 a_1317_987.t1 VSS 0.35678f
C49 a_1317_987.n0 VSS 0.78052f
C50 a_1317_987.n1 VSS 0.17506f
C51 a_1317_987.t2 VSS 0.17822f
C52 VSS.t6 VSS 0.30233f
C53 VSS.t1 VSS 0.55375f
C54 VSS.t3 VSS 0.36237f
C55 VDD.n1 VSS 0.31276f
C56 VDD.n24 VSS 0.15218f
C57 VDD.t19 VSS 0.11374f
C58 VDD.t17 VSS 0.11526f
C59 VDD.t8 VSS 0.10266f
C60 VDD.n35 VSS 0.10536f
C61 VDD.t6 VSS 0.129f
C62 VDD.t4 VSS 0.12723f
C63 VDD.n39 VSS 0.15218f
C64 VDD.n41 VSS 0.10536f
C65 VDD.n42 VSS 0.14048f
C66 VDD.n46 VSS 0.10536f
C67 VDD.n47 VSS 0.11707f
C68 VDD.n51 VSS 0.15218f
C69 VDD.n52 VSS 0.14706f
C70 VDD.n55 VSS 0.10024f
C71 VDD.n56 VSS 0.11706f
C72 VDD.n57 VSS 0.11048f
C73 VDD.n60 VSS 0.15731f
C74 VDD.n61 VSS 0.14048f
C75 VDD.n62 VSS 0.10536f
C76 VDD.n66 VSS 0.24584f
C77 VDD.n67 VSS 0.11246f
C78 VDD.n68 VSS 0.11246f
C79 VDD.n69 VSS 0.2751f
C80 VDD.n70 VSS 0.15218f
C81 A.n1 VSS 0.13771f
C82 A.n2 VSS 0.27036f
C83 A.n3 VSS 0.41915f
C84 A.n6 VSS 0.1907f
C85 A.n7 VSS 0.20888f
C86 A.n16 VSS 0.66267f
C87 B.n0 VSS 0.94169f
C88 B.n1 VSS 0.22537f
C89 B.n2 VSS 0.33718f
C90 Y.t0 VSS 0.32299f
C91 Y.n1 VSS 0.13144f
C92 Y.t3 VSS 0.1466f
C93 Y.t1 VSS 0.12737f
C94 Y.n6 VSS 0.14334f
C95 Y.t2 VSS 0.14266f
C96 Y.t4 VSS 0.16671f
C97 Y.n7 VSS 0.21281f
C98 Y.n11 VSS 0.12527f
C99 Y.n14 VSS 0.10179f
C100 Y.n17 VSS 0.76719f
C101 Y.n19 VSS 0.12345f
C102 Y.n21 VSS 0.10694f
C103 Y.n25 VSS 0.17676f
.ends
