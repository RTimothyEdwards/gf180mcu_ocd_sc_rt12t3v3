* NGSPICE file created from gf180mcu_ocd_sc_rt12t3v3__tiel.ext - technology: gf180mcuD

.subckt gf180mcu_ocd_sc_rt12t3v3__tiel Y VDD VSS
X0 VDD.t3 a_93_147.t2 a_93_147.t3 VDD.t2 pfet_03v3 ad=2.7424p pd=12.83u as=0.3341p ps=1.805u w=1.285u l=0.28u
X1 a_93_147.t1 a_93_147.t0 VDD.t1 VDD.t0 pfet_03v3 ad=0.3341p pd=1.805u as=2.7424p ps=12.83u w=1.285u l=0.28u
X2 Y.t0 a_93_147.t4 VSS.t1 VSS.t0 nfet_03v3 ad=0.3087p pd=2.01u as=4.22095p ps=23.13u w=1.02u l=0.28u
R0 Y.t0 Y.n0 3.32853
R1 Y Y.t0 7.2019
R2 VDD.n28 VDD.n14 137.088
R3 VDD.n24 VDD.n23 137.088
R4 VDD.n22 VDD.n0 137.088
R5 VDD.t0 VDD.n14 117.504
R6 VDD.t2 VDD.n22 97.9197
R7 VDD.n19 VDD.n15 74.5982
R8 VDD.n23 VDD.t2 39.1682
R9 VDD.n24 VDD.t0 19.5843
R10 VDD.n29 VDD.n13 9.8005
R11 VDD.n25 VDD.n11 2.75725
R12 VDD.n25 VDD.n17 9.8005
R13 VDD.n21 VDD.n17 9.8005
R14 VDD.n10 VDD.n20 4.85219
R15 VDD.n8 VDD.n18 5.40705
R16 VDD VDD.n19 6.51963
R17 VDD.n29 VDD.n28 6.3005
R18 VDD VDD.n29 6.3005
R19 VDD.n14 VDD.n13 6.3005
R20 VDD.n13 VDD.n11 2.75725
R21 VDD.n25 VDD.n24 6.3005
R22 VDD VDD.n11 1.77287
R23 VDD.n23 VDD.n17 6.3005
R24 VDD.n17 VDD 6.3005
R25 VDD.n22 VDD.n21 6.3005
R26 VDD.n21 VDD.n10 2.75725
R27 VDD VDD.n10 1.77287
R28 VDD.n12 VDD 6.3005
R29 VDD.n6 VDD.n7 1.85802
R30 VDD.n9 VDD.n7 2.22249
R31 VDD.n28 VDD.n15 6.3005
R32 VDD VDD.n8 1.82635
R33 VDD.n1 VDD.n0 2.13272
R34 VDD.n4 VDD.n1 2.03756
R35 VDD.n4 VDD.n2 2.101
R36 VDD VDD.n2 2.101
R37 VDD.n20 VDD.n2 4.19594
R38 VDD.n29 VDD.n12 6.19113
R39 VDD.n1 VDD.n8 4.68735
R40 VDD.n26 VDD.n16 5.35538
R41 VDD.n16 VDD.n7 4.48286
R42 VDD.n5 VDD 2.91159
R43 VDD VDD.n3 2.90963
R44 VDD.n26 VDD.n15 2.82549
R45 VDD.n19 VDD.n18 2.75725
R46 VDD.n28 VDD.n27 2.1923
R47 VDD.n20 VDD.n0 2.10378
R48 VDD.n9 VDD.n26 2.03587
R49 VDD.n27 VDD.n12 1.91839
R50 VDD.n27 VDD.n6 1.91839
R51 VDD.n28 VDD.n16 1.83883
R52 VDD.n18 VDD.n0 1.77287
R53 VDD.n9 VDD 1.71963
R54 VDD.n5 VDD.t1 1.41684
R55 VDD.n3 VDD.t3 1.41684
R56 VDD.n4 VDD.n3 1.26229
R57 VDD.n6 VDD.n5 1.22714
R58 VSS.n15 VSS.n12 452.993
R59 VSS.n23 VSS.n8 452.736
R60 VSS.n18 VSS.n12 452.736
R61 VSS.t0 VSS.n8 254.665
R62 VSS.n18 VSS.t0 198.072
R63 VSS.n17 VSS.n5 10.8894
R64 VSS.n17 VSS.n13 10.8894
R65 VSS.n1 VSS.n19 2.66071
R66 VSS.n19 VSS.n11 10.8894
R67 VSS.n22 VSS.n6 10.4384
R68 VSS.n25 VSS.n2 9.76841
R69 VSS.n16 VSS.n15 7.43544
R70 VSS.n15 VSS.n14 7.43544
R71 VSS.n5 VSS.n7 7.38939
R72 VSS.n21 VSS.n20 7.38939
R73 VSS.n22 VSS.n4 2.35671
R74 VSS VSS.n25 5.2005
R75 VSS.n7 VSS 5.2005
R76 VSS.n23 VSS.n22 5.2005
R77 VSS.n4 VSS 1.074
R78 VSS.n23 VSS.n2 5.2005
R79 VSS.n2 VSS 5.2005
R80 VSS VSS.n21 5.2005
R81 VSS VSS.n6 5.2005
R82 VSS.n12 VSS.n11 5.2005
R83 VSS.n19 VSS.n18 5.2005
R84 VSS.n1 VSS.n0 1.27115
R85 VSS.n20 VSS.n8 5.2005
R86 VSS.n20 VSS.n1 2.66071
R87 VSS.n5 VSS.n8 5.2005
R88 VSS VSS.n5 5.2005
R89 VSS.n18 VSS.n17 5.2005
R90 VSS.n17 VSS 5.2005
R91 VSS.n13 VSS.n12 5.2005
R92 VSS.n3 VSS.n10 4.5995
R93 VSS.n3 VSS.t1 4.4105
R94 VSS.n4 VSS.n3 1.42802
R95 VSS.n3 VSS.n2 2.71962
R96 VSS.n24 VSS.n7 2.66071
R97 VSS.n6 VSS.n9 2.66071
R98 VSS.n21 VSS.n9 2.66071
R99 VSS.n25 VSS.n24 2.66071
R100 VSS.n14 VSS.n11 2.63361
R101 VSS.n16 VSS.n13 2.63361
R102 VSS VSS.n16 1.53032
R103 VSS.n14 VSS.n0 1.53032
R104 VSS.n24 VSS.n23 1.27115
R105 VSS.n23 VSS.n9 1.27115
R106 VSS VSS.n0 1.00862
R107 a_93_147.n0 a_93_147.t2 29.4322
R108 a_93_147.n0 a_93_147.t0 25.3767
R109 a_93_147.n1 a_93_147.n0 4.0005
R110 a_93_147.n2 a_93_147.n1 2.96637
R111 a_93_147.n1 a_93_147.t4 8.45646
R112 a_93_147.t1 a_93_147.n2 1.41684
R113 a_93_147.n2 a_93_147.t3 1.41684
C0 VDD Y 0.21426f
C1 Y VSS 0.68567f
C2 VDD VSS 2.34614f
C3 a_93_147.t4 VSS 0.35526f
C4 a_93_147.n1 VSS 0.37228f
C5 VDD.n0 VSS 0.14014f
C6 VDD.n28 VSS 0.14014f
C7 Y.t0 VSS 0.12103f
C8 Y.n0 VSS 0.12844f
.ends
