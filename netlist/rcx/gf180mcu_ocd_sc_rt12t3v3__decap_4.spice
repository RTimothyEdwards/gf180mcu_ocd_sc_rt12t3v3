* NGSPICE file created from gf180mcu_ocd_sc_rt12t3v3__decap_4.ext - technology: gf180mcuD

.subckt gf180mcu_ocd_sc_rt12t3v3__decap_4 VDD VSS
X0 a_146_799# a_56_147.t1 VSS.t1 VSS.t0 nfet_03v3 ad=0.35p pd=2.15u as=3.935p ps=20.89u w=1.09u l=0.28u
X1 a_56_147.t0 a_146_799# VDD.t1 VDD.t0 pfet_03v3 ad=0.9178p pd=4.57u as=4.38315p ps=21.8u w=1.765u l=0.53u
R0 VDD.n19 VDD.n18 162.409
R1 VDD.n20 VDD.n19 161.851
R2 VDD.n15 VDD.n9 161.851
R3 VDD.n24 VDD.n9 161.851
R4 VDD.n20 VDD.t0 85.2606
R5 VDD.n15 VDD.t0 76.5901
R6 VDD.n21 VDD.n13 9.8005
R7 VDD.n21 VDD.n11 9.8005
R8 VDD.n22 VDD.n4 2.75725
R9 VDD.n10 VDD.n6 9.8005
R10 VDD.n23 VDD.n5 2.75725
R11 VDD.n18 VDD.n12 8.0105
R12 VDD.n18 VDD.n17 7.99369
R13 VDD.n14 VDD.n2 7.50688
R14 VDD.n16 VDD.n7 7.50688
R15 VDD.n23 VDD.n22 6.6505
R16 VDD.n26 VDD.n7 6.40476
R17 VDD VDD.n26 6.3005
R18 VDD VDD.n6 6.3005
R19 VDD.n3 VDD.n10 6.3005
R20 VDD.n24 VDD.n23 6.3005
R21 VDD.n5 VDD.n3 1.77287
R22 VDD.n16 VDD.n15 6.3005
R23 VDD VDD.n16 6.3005
R24 VDD.n9 VDD.n7 6.3005
R25 VDD.n7 VDD 6.3005
R26 VDD.n20 VDD.n2 6.3005
R27 VDD.n0 VDD.n2 2.01122
R28 VDD.n19 VDD.n14 6.3005
R29 VDD.n19 VDD.n13 6.3005
R30 VDD.n21 VDD.n20 6.3005
R31 VDD.n3 VDD.n21 6.3005
R32 VDD.n15 VDD.n11 6.3005
R33 VDD.n4 VDD.n11 2.75725
R34 VDD.n22 VDD.n9 6.3005
R35 VDD.n4 VDD.n3 1.77287
R36 VDD.n1 VDD.n0 0.683304
R37 VDD.n16 VDD.n1 3.55263
R38 VDD.n26 VDD.n25 2.75725
R39 VDD.n10 VDD.n8 2.75725
R40 VDD.n25 VDD.n6 2.75725
R41 VDD.n5 VDD.n8 5.514
R42 VDD.n13 VDD.n12 2.73055
R43 VDD.n17 VDD.n14 2.71431
R44 VDD.n0 VDD 1.08806
R45 VDD.n17 VDD 2.04413
R46 VDD.n3 VDD.n12 2.03587
R47 VDD.n25 VDD.n24 1.77287
R48 VDD.n24 VDD.n8 1.77287
R49 VDD.n1 VDD.t1 1.74554
R50 VDD.n3 VDD 1.4165
R51 VSS.n12 VSS.n9 526.318
R52 VSS.n19 VSS.n5 526.013
R53 VSS.n15 VSS.n9 526.013
R54 VSS.t0 VSS.n5 295.882
R55 VSS.n15 VSS.t0 230.131
R56 VSS.n0 VSS.n16 2.66071
R57 VSS.n16 VSS.n8 10.8894
R58 VSS.n14 VSS.n4 10.8894
R59 VSS.n14 VSS.n10 10.8894
R60 VSS.n2 VSS.n3 9.44628
R61 VSS.n2 VSS.n1 1.15303
R62 VSS.n18 VSS.n17 7.38939
R63 VSS.n21 VSS.n4 7.38939
R64 VSS.n12 VSS.n11 7.3326
R65 VSS.n13 VSS.n12 7.3326
R66 VSS VSS.n18 5.2005
R67 VSS.n17 VSS.n5 5.2005
R68 VSS.n17 VSS.n0 2.66071
R69 VSS.n16 VSS.n15 5.2005
R70 VSS.n0 VSS 1.27115
R71 VSS.n9 VSS.n8 5.2005
R72 VSS.n20 VSS.n1 5.58733
R73 VSS.n19 VSS.n2 5.2005
R74 VSS VSS.n3 5.2005
R75 VSS VSS.n21 5.2005
R76 VSS.n10 VSS.n9 5.2005
R77 VSS.n15 VSS.n14 5.2005
R78 VSS.n14 VSS 5.2005
R79 VSS.n5 VSS.n4 5.2005
R80 VSS.n4 VSS 5.2005
R81 VSS.n2 VSS.n7 5.0405
R82 VSS.n2 VSS.t1 4.92172
R83 VSS.n18 VSS.n6 2.64212
R84 VSS.n3 VSS.n6 2.64212
R85 VSS.n21 VSS.n20 2.64212
R86 VSS.n11 VSS.n8 2.63361
R87 VSS.n13 VSS.n10 2.63361
R88 VSS.n11 VSS 1.53032
R89 VSS VSS.n13 1.53032
R90 VSS.n1 VSS 1.51698
R91 VSS.n19 VSS.n6 1.28044
R92 VSS.n20 VSS.n19 1.28044
R93 a_56_147.t0 a_56_147.t1 10.2659
C0 VDD a_146_799# 0.38335f
C1 VDD VSS 2.00797f
C2 a_146_799# VSS 0.44201f
C3 a_56_147.t1 VSS 0.50524f
C4 a_56_147.t0 VSS 0.3469f
C5 VDD.n18 VSS 0.14253f
C6 VDD.n24 VSS 0.12281f
.ends
