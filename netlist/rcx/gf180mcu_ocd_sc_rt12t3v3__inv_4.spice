* NGSPICE file created from gf180mcu_ocd_sc_rt12t3v3__inv_4.ext - technology: gf180mcuD

.subckt gf180mcu_ocd_sc_rt12t3v3__inv_4 A Y VDD VSS
X0 Y.t8 A.t1 VSS.t5 VSS.t4 nfet_03v3 ad=0.3087p pd=2.01u as=4.2213p ps=21.07u w=1.02u l=0.28u
X1 VDD.t11 A.t4 Y.t3 VDD.t10 pfet_03v3 ad=0.8721p pd=4.44u as=0.4446p ps=2.23u w=1.71u l=0.28u
X2 Y.t7 A.t7 VDD.t5 VDD.t4 pfet_03v3 ad=0.4446p pd=2.23u as=0.4446p ps=2.23u w=1.71u l=0.28u
X3 Y.t4 A.t0 VSS.t7 VSS.t6 nfet_03v3 ad=0.3087p pd=2.01u as=4.2213p ps=21.07u w=1.02u l=0.28u
X4 Y.t0 A.t9 VDD.t1 VDD.t0 pfet_03v3 ad=0.4446p pd=2.23u as=0.7524p ps=4.3u w=1.71u l=0.28u
X5 VDD.t7 A.t6 Y.t6 VDD.t6 pfet_03v3 ad=0.4446p pd=2.23u as=0.4446p ps=2.23u w=1.71u l=0.28u
X6 Y.t1 A.t3 VSS.t1 VSS.t0 nfet_03v3 ad=0.3087p pd=2.01u as=4.2213p ps=21.07u w=1.02u l=0.28u
X7 VDD.t3 A.t8 Y.t2 VDD.t2 pfet_03v3 ad=0.4446p pd=2.23u as=0.4446p ps=2.23u w=1.71u l=0.28u
X8 Y.t5 A.t5 VDD.t9 VDD.t8 pfet_03v3 ad=0.4446p pd=2.23u as=0.4446p ps=2.23u w=1.71u l=0.28u
X9 Y.t9 A.t2 VSS.t3 VSS.t2 nfet_03v3 ad=0.3087p pd=2.01u as=4.2213p ps=21.07u w=1.02u l=0.28u
R0 Y.n28 Y.t4 50.9005
R1 Y.n26 Y.t8 50.9005
R2 Y.n24 Y.t9 50.9005
R3 Y.n22 Y.t1 50.9005
R4 Y.n11 Y.n29 32.5888
R5 Y.n8 Y.n27 32.5888
R6 Y.n5 Y.n25 32.5888
R7 Y.n2 Y.n23 32.5888
R8 Y.n29 Y.n28 19.8599
R9 Y.n27 Y.n26 19.8599
R10 Y.n25 Y.n24 19.8599
R11 Y.n23 Y.n22 16.9387
R12 Y.n28 Y.n9 11.9058
R13 Y.n26 Y.n6 11.9058
R14 Y.n24 Y.n3 11.9058
R15 Y.n22 Y.n0 11.9058
R16 Y.n13 Y.n17 6.86789
R17 Y.n13 Y.n16 6.3005
R18 Y.n13 Y.n15 6.3005
R19 Y Y.n14 6.3005
R20 Y.n14 Y.n9 3.31861
R21 Y.n15 Y.n6 3.31861
R22 Y.n16 Y.n3 3.31861
R23 Y.n17 Y.n0 3.31861
R24 Y.n29 Y.n18 3.6505
R25 Y.n27 Y.n19 3.6505
R26 Y.n25 Y.n20 3.6505
R27 Y.n23 Y.n21 3.6505
R28 Y.n12 Y.n32 2.57905
R29 Y.n11 Y.n9 0.0474974
R30 Y.n8 Y.n6 0.0474974
R31 Y.n5 Y.n3 0.0474974
R32 Y.n2 Y.n0 0.0474974
R33 Y.n12 Y.n31 1.95688
R34 Y.n12 Y.n30 1.95492
R35 Y.n10 Y.t4 0.459182
R36 Y.n7 Y.t8 0.459182
R37 Y.n4 Y.t9 0.459182
R38 Y.n1 Y.t1 0.459182
R39 Y.n10 Y.n18 0.825727
R40 Y.n7 Y.n19 0.825727
R41 Y.n4 Y.n20 0.825727
R42 Y.n1 Y.n21 0.825727
R43 Y.n32 Y.t0 1.06483
R44 Y.n32 Y.t2 1.06483
R45 Y.n31 Y.t7 1.06483
R46 Y.n31 Y.t6 1.06483
R47 Y.n30 Y.t5 1.06483
R48 Y.n30 Y.t3 1.06483
R49 Y.n14 Y.t4 5.88322
R50 Y.n15 Y.t8 5.88322
R51 Y.n16 Y.t9 5.88322
R52 Y.n17 Y.t1 5.88322
R53 Y Y.n12 2.3405
R54 Y.n17 Y.n21 1.7588
R55 Y.n16 Y.n20 1.7588
R56 Y.n15 Y.n19 1.7588
R57 Y.n14 Y.n18 1.7588
R58 Y.n11 Y.n10 1.57306
R59 Y.n8 Y.n7 1.57306
R60 Y.n5 Y.n4 1.57306
R61 Y.n2 Y.n1 1.57306
R62 Y Y.n13 1.33289
R63 A.n18 A.n0 62.6336
R64 A.n13 A.t9 41.1209
R65 A.n11 A.t4 41.1209
R66 A.n1 A.n17 34.674
R67 A.n22 A.n16 33.6709
R68 A.n13 A.t8 24.8987
R69 A.n14 A.t7 24.8987
R70 A.n12 A.t6 24.8987
R71 A.n11 A.t5 24.8987
R72 A.n22 A.n21 20.7052
R73 A.n21 A.n17 20.7052
R74 A.n14 A.n13 16.2227
R75 A.n12 A.n11 16.2227
R76 A.n24 A.n16 13.6738
R77 A.n20 A.n5 13.4728
R78 A.n25 A.n2 3.92668
R79 A.n6 A.n5 8.21487
R80 A.n15 A.n14 8.213
R81 A.n15 A.n12 8.01022
R82 A.n18 A.n1 7.46641
R83 A.n5 A.n10 2.63171
R84 A.n10 A.t1 0.786163
R85 A.n25 A.t2 5.85149
R86 A.n19 A.n0 8.62113
R87 A.n24 A.n23 5.60586
R88 A.n6 A.n4 5.31982
R89 A.n10 A.n9 6.16855
R90 A.n9 A.n18 4.47523
R91 A.t0 A.n1 3.97415
R92 A.n7 A.n6 1.22667
R93 A.n9 A.n8 1.22681
R94 A.t1 A.n8 5.30638
R95 A.n3 A.t3 0.410838
R96 A.n7 A.t2 5.30642
R97 A.n26 A.n25 3.61125
R98 A.t0 A.n0 0.169115
R99 A.n23 A.n2 3.38298
R100 A.n26 A.n4 2.71069
R101 A A.n15 1.97917
R102 A.t3 A.n24 1.95586
R103 A.t2 A.n4 1.88705
R104 A.n2 A.n3 1.59182
R105 A.n19 A.n17 1.17406
R106 A.n21 A.n20 1.17406
R107 A.n23 A.n22 1.17406
R108 A.n3 A.n16 2.59122
R109 A.n19 A.n8 3.11501
R110 A.n7 A.n20 3.11496
R111 A A.n26 1.84085
R112 VDD.n42 VDD.n41 186.852
R113 VDD.n44 VDD.n43 137.088
R114 VDD.n29 VDD.n27 137.088
R115 VDD.n31 VDD.n26 137.088
R116 VDD.t10 VDD.n35 137.088
R117 VDD.t10 VDD.n21 137.088
R118 VDD.n21 VDD.n18 137.088
R119 VDD.n40 VDD.n18 137.088
R120 VDD.n44 VDD.t0 117.504
R121 VDD.n34 VDD.t6 117.504
R122 VDD.n30 VDD.t2 97.9197
R123 VDD.t4 VDD.n30 97.9197
R124 VDD.t8 VDD.n34 78.3359
R125 VDD.n35 VDD.t8 58.752
R126 VDD.t2 VDD.n29 39.1682
R127 VDD.n31 VDD.t4 39.1682
R128 VDD.n27 VDD.t0 19.5843
R129 VDD.n26 VDD.t6 19.5843
R130 VDD.n2 VDD.n17 5.514
R131 VDD.n46 VDD.n45 9.8005
R132 VDD.n45 VDD.n6 2.75725
R133 VDD.n28 VDD.n10 9.8005
R134 VDD.n3 VDD.n25 2.75725
R135 VDD.n32 VDD.n25 9.8005
R136 VDD.n32 VDD.n22 9.8005
R137 VDD.n5 VDD.n22 2.75725
R138 VDD.n33 VDD.n20 9.8005
R139 VDD.n36 VDD.n20 9.8005
R140 VDD.n36 VDD.n7 2.75725
R141 VDD.n37 VDD.n8 9.8005
R142 VDD.n4 VDD.n37 2.75725
R143 VDD.n15 VDD.n12 9.8005
R144 VDD.n14 VDD.n13 9.8005
R145 VDD.n39 VDD.n38 6.6505
R146 VDD VDD.n46 6.3005
R147 VDD.n45 VDD.n44 6.3005
R148 VDD.n6 VDD 1.77287
R149 VDD.n27 VDD.n10 6.3005
R150 VDD.n6 VDD.n10 2.75725
R151 VDD.n29 VDD.n28 6.3005
R152 VDD.n28 VDD.n3 2.75725
R153 VDD.n30 VDD.n25 6.3005
R154 VDD.n3 VDD 1.77287
R155 VDD.n32 VDD.n31 6.3005
R156 VDD VDD.n32 6.3005
R157 VDD.n26 VDD.n22 6.3005
R158 VDD VDD.n5 1.77287
R159 VDD.n34 VDD.n33 6.3005
R160 VDD.n33 VDD.n5 2.75725
R161 VDD.n35 VDD.n20 6.3005
R162 VDD.n20 VDD.n0 6.3005
R163 VDD.n36 VDD.t10 6.3005
R164 VDD.n0 VDD.n7 1.77287
R165 VDD.n21 VDD.n8 6.3005
R166 VDD.n7 VDD.n8 2.75725
R167 VDD.n37 VDD.n18 6.3005
R168 VDD.n4 VDD.n0 1.77287
R169 VDD.n40 VDD.n39 6.3005
R170 VDD.n39 VDD.n4 2.75725
R171 VDD.n41 VDD.n40 6.3005
R172 VDD.n2 VDD.n0 1.77287
R173 VDD.n38 VDD.n0 6.3005
R174 VDD.n13 VDD 6.3005
R175 VDD VDD.n14 6.3005
R176 VDD VDD.n15 6.3005
R177 VDD.n43 VDD.n12 6.3005
R178 VDD.n43 VDD.n42 6.3005
R179 VDD.n17 VDD.n1 5.4873
R180 VDD.n0 VDD.t11 3.97983
R181 VDD VDD.t1 3.20316
R182 VDD VDD.n24 2.9155
R183 VDD VDD.n23 2.91354
R184 VDD.n41 VDD.n1 2.82549
R185 VDD.n42 VDD.n16 2.82549
R186 VDD.n38 VDD.n19 2.75725
R187 VDD.n2 VDD.n19 5.514
R188 VDD.n15 VDD.n11 2.75725
R189 VDD.n14 VDD.n11 2.75725
R190 VDD.n16 VDD.n12 2.73055
R191 VDD.n13 VDD.n9 2.17736
R192 VDD.n46 VDD.n9 2.17736
R193 VDD VDD.n0 2.0885
R194 VDD.n43 VDD.n9 2.06282
R195 VDD.n0 VDD.n1 2.03587
R196 VDD.n16 VDD 2.03587
R197 VDD.n40 VDD.n17 1.77287
R198 VDD.n40 VDD.n19 1.77287
R199 VDD.n43 VDD.n11 1.77287
R200 VDD.n23 VDD.t7 1.06483
R201 VDD.n23 VDD.t9 1.06483
R202 VDD.n24 VDD.t3 1.06483
R203 VDD.n24 VDD.t5 1.06483
R204 VSS.n46 VSS.n45 513.399
R205 VSS.n27 VSS.n26 513.399
R206 VSS.n28 VSS.n27 513.399
R207 VSS.n32 VSS.n31 513.399
R208 VSS.n33 VSS.n20 513.399
R209 VSS.n36 VSS.n20 513.399
R210 VSS.n38 VSS.n37 513.399
R211 VSS.n38 VSS.n18 513.399
R212 VSS.n31 VSS.t2 495.063
R213 VSS.n37 VSS.t6 403.385
R214 VSS.t4 VSS.n32 320.875
R215 VSS.n26 VSS.t0 284.204
R216 VSS.n46 VSS.t0 229.196
R217 VSS.n43 VSS.n42 220.447
R218 VSS.n33 VSS.t4 192.525
R219 VSS.t6 VSS.n36 110.014
R220 VSS.n28 VSS.t2 18.3362
R221 VSS.n39 VSS.n19 10.8894
R222 VSS.n47 VSS.n17 10.8894
R223 VSS.n15 VSS.n5 2.57159
R224 VSS.n29 VSS.n25 10.1678
R225 VSS.n30 VSS.n16 9.83283
R226 VSS.n11 VSS.n16 2.52122
R227 VSS.n14 VSS.n3 2.49357
R228 VSS.n47 VSS.n9 9.52359
R229 VSS.n25 VSS 2.62691
R230 VSS.n35 VSS.n4 8.18122
R231 VSS.n12 VSS.n17 7.38939
R232 VSS.n6 VSS.n5 6.83183
R233 VSS.n29 VSS.n7 6.49448
R234 VSS VSS.n43 5.41963
R235 VSS.n42 VSS 5.41963
R236 VSS.n47 VSS.n46 5.2005
R237 VSS VSS.n47 5.2005
R238 VSS.n45 VSS.n17 5.2005
R239 VSS.n17 VSS 5.2005
R240 VSS.n27 VSS.n25 5.2005
R241 VSS.n26 VSS.n9 5.2005
R242 VSS.n9 VSS 5.2005
R243 VSS.n31 VSS.n30 5.2005
R244 VSS.n8 VSS 1.45033
R245 VSS.n29 VSS.n28 5.2005
R246 VSS VSS.n29 5.2005
R247 VSS.n32 VSS.n16 5.2005
R248 VSS VSS.n11 1.34089
R249 VSS.n5 VSS.n20 5.2005
R250 VSS VSS.n15 1.31571
R251 VSS.n34 VSS.n33 5.2005
R252 VSS.n34 VSS.n11 2.52122
R253 VSS.n37 VSS.n3 5.2005
R254 VSS VSS.n14 1.35472
R255 VSS.n36 VSS.n35 5.2005
R256 VSS.n35 VSS.n15 2.57159
R257 VSS.n19 VSS.n18 5.2005
R258 VSS.n13 VSS.n19 2.1609
R259 VSS.n39 VSS.n38 5.2005
R260 VSS.n14 VSS.n39 2.49357
R261 VSS.n40 VSS.n2 5.32092
R262 VSS.n13 VSS 1.52105
R263 VSS VSS.n12 5.2005
R264 VSS VSS.n1 1.27115
R265 VSS.n4 VSS.t7 4.4105
R266 VSS.n6 VSS.t5 4.4105
R267 VSS.n7 VSS.t3 4.4105
R268 VSS.n10 VSS.t1 4.4105
R269 VSS VSS.n10 1.59169
R270 VSS.n8 VSS.n7 0.823717
R271 VSS VSS.n6 3.1505
R272 VSS VSS.n4 3.1505
R273 VSS.n30 VSS.n8 1.35914
R274 VSS.n4 VSS.n21 2.7725
R275 VSS.n6 VSS.n22 2.7725
R276 VSS.n10 VSS.n24 2.7725
R277 VSS.n43 VSS.n0 2.66071
R278 VSS.n42 VSS.n41 2.66071
R279 VSS.n44 VSS.n12 2.66071
R280 VSS.n44 VSS.n1 5.32092
R281 VSS.n1 VSS.n0 5.32092
R282 VSS.n40 VSS.n13 4.82111
R283 VSS.n7 VSS.n23 2.9615
R284 VSS.n6 VSS.n34 2.80396
R285 VSS.n41 VSS.n2 5.32092
R286 VSS.n2 VSS 2.24271
R287 VSS.n4 VSS.n3 1.45456
R288 VSS.n41 VSS.n18 1.27115
R289 VSS.n40 VSS.n18 1.27115
R290 VSS.n45 VSS.n44 1.27115
R291 VSS.n45 VSS.n0 1.27115
R292 VSS.n10 VSS.n9 1.11721
C0 VDD Y 0.82422f
C1 VDD A 1.15889f
C2 Y A 1.042f
C3 Y VSS 0.54916f
C4 A VSS 1.7765f
C5 VDD VSS 4.372f
C6 VDD.n0 VSS 0.10776f
C7 VDD.n40 VSS 0.14827f
C8 VDD.n43 VSS 0.14827f
C9 A.n1 VSS 0.10023f
C10 A.n16 VSS 0.14708f
C11 A.n17 VSS 0.10426f
C12 A.n22 VSS 0.10803f
C13 Y.n12 VSS 0.32039f
C14 Y.n13 VSS 0.13184f
.ends
