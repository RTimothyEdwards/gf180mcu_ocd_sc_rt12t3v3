* NGSPICE file created from gf180mcu_ocd_sc_rt12t3v3__inv_4.ext - technology: gf180mcuD

.subckt gf180mcu_ocd_sc_rt12t3v3__inv_4 A Y VDD VSS
X0 Y.t9 A.t1 VSS.t5 VSS.t4 nfet_03v3 ad=0.3087p pd=2.01u as=4.2213p ps=21.07u w=1.02u l=0.28u
X1 VDD.t11 A.t4 Y.t7 VDD.t10 pfet_03v3 ad=0.8721p pd=4.44u as=0.4446p ps=2.23u w=1.71u l=0.28u
X2 Y.t6 A.t7 VDD.t5 VDD.t4 pfet_03v3 ad=0.4446p pd=2.23u as=0.4446p ps=2.23u w=1.71u l=0.28u
X3 Y.t2 A.t0 VSS.t7 VSS.t6 nfet_03v3 ad=0.3087p pd=2.01u as=4.2213p ps=21.07u w=1.02u l=0.28u
X4 Y.t3 A.t9 VDD.t1 VDD.t0 pfet_03v3 ad=0.4446p pd=2.23u as=0.7524p ps=4.3u w=1.71u l=0.28u
X5 VDD.t7 A.t6 Y.t0 VDD.t6 pfet_03v3 ad=0.4446p pd=2.23u as=0.4446p ps=2.23u w=1.71u l=0.28u
X6 Y.t1 A.t3 VSS.t1 VSS.t0 nfet_03v3 ad=0.3087p pd=2.01u as=4.2213p ps=21.07u w=1.02u l=0.28u
X7 VDD.t3 A.t8 Y.t8 VDD.t2 pfet_03v3 ad=0.4446p pd=2.23u as=0.4446p ps=2.23u w=1.71u l=0.28u
X8 Y.t5 A.t5 VDD.t9 VDD.t8 pfet_03v3 ad=0.4446p pd=2.23u as=0.4446p ps=2.23u w=1.71u l=0.28u
X9 Y.t4 A.t2 VSS.t3 VSS.t2 nfet_03v3 ad=0.3087p pd=2.01u as=4.2213p ps=21.07u w=1.02u l=0.28u
R0 Y.n8 Y.n2 3.37947
R1 Y.n7 Y.n3 3.37947
R2 Y.n6 Y.n4 3.37947
R3 Y.n1 Y.n4 6.88006
R4 Y.n1 Y.n3 6.88006
R5 Y Y.n2 6.88006
R6 Y.t2 Y.n2 0.645433
R7 Y.t9 Y.n3 0.645433
R8 Y.t4 Y.n4 0.645433
R9 Y.t1 Y.n5 3.32853
R10 Y.n0 Y.n11 2.57905
R11 Y.n0 Y.n10 1.95688
R12 Y.n0 Y.n9 1.95492
R13 Y.n1 Y.t1 7.57034
R14 Y Y.n0 2.3405
R15 Y Y.n1 1.33289
R16 Y.n11 Y.t3 1.06483
R17 Y.n11 Y.t8 1.06483
R18 Y.n10 Y.t6 1.06483
R19 Y.n10 Y.t0 1.06483
R20 Y.n9 Y.t5 1.06483
R21 Y.n9 Y.t7 1.06483
R22 A.n7 A.n6 102.201
R23 A.n26 A.t0 102.201
R24 A.n26 A.n24 59.0234
R25 A.t0 A.n6 54.7505
R26 A.n5 A.n4 3.95491
R27 A.n3 A.n2 3.95491
R28 A.t2 A.n1 34.4074
R29 A.n21 A.t9 41.1209
R30 A.n19 A.t4 41.1209
R31 A.n24 A.n14 41.8903
R32 A.n28 A.t3 34.7414
R33 A.n21 A.t8 24.8987
R34 A.n22 A.t7 24.8987
R35 A.n20 A.t6 24.8987
R36 A.n19 A.t5 24.8987
R37 A.n22 A.n21 16.2227
R38 A.n20 A.n19 16.2227
R39 A.n23 A.n22 8.213
R40 A.n23 A.n20 8.01022
R41 A.n9 A.n25 39.8695
R42 A.n11 A.t3 5.12857
R43 A.n13 A.n27 5.60586
R44 A.n9 A.t1 2.33529
R45 A.n5 A.n10 2.80342
R46 A.n11 A.n3 2.80342
R47 A.n16 A.n14 21.1446
R48 A.n16 A.n18 21.1446
R49 A.n18 A.n28 39.8945
R50 A.n25 A.n4 6.60013
R51 A.n27 A.n26 3.6505
R52 A.n15 A.n4 24.3508
R53 A.n17 A.n2 24.3508
R54 A.t2 A.n10 5.37191
R55 A.n29 A.n1 4.82737
R56 A.n14 A.n13 0.831752
R57 A.n13 A.n9 1.25151
R58 A.n16 A.n15 0.831752
R59 A.n10 A.n15 1.25151
R60 A.n18 A.n17 0.831752
R61 A.n17 A.n11 1.25151
R62 A.n12 A.t0 0.739898
R63 A.n30 A.n0 2.71069
R64 A.n30 A.n29 2.37947
R65 A A.n23 1.97917
R66 A.n27 A.n6 1.95586
R67 A.n1 A.n0 0.590562
R68 A.n29 A.n2 3.69332
R69 A.n12 A.n7 3.74312
R70 A.n7 A.n8 0.508761
R71 A.n12 A.n24 2.82559
R72 A.n5 A.n0 2.65673
R73 A A.n30 1.84085
R74 A.n8 A.t1 0.453453
R75 A.n3 A.n28 2.36189
R76 A.n25 A.n8 2.37702
R77 VDD.n42 VDD.n41 186.852
R78 VDD.n44 VDD.n43 137.088
R79 VDD.n29 VDD.n27 137.088
R80 VDD.n31 VDD.n26 137.088
R81 VDD.t10 VDD.n35 137.088
R82 VDD.t10 VDD.n21 137.088
R83 VDD.n21 VDD.n18 137.088
R84 VDD.n40 VDD.n18 137.088
R85 VDD.n44 VDD.t0 117.504
R86 VDD.n34 VDD.t6 117.504
R87 VDD.n30 VDD.t2 97.9197
R88 VDD.t4 VDD.n30 97.9197
R89 VDD.t8 VDD.n34 78.3359
R90 VDD.n35 VDD.t8 58.752
R91 VDD.t2 VDD.n29 39.1682
R92 VDD.n31 VDD.t4 39.1682
R93 VDD.n27 VDD.t0 19.5843
R94 VDD.n26 VDD.t6 19.5843
R95 VDD.n2 VDD.n17 5.514
R96 VDD.n46 VDD.n45 9.8005
R97 VDD.n45 VDD.n6 2.75725
R98 VDD.n28 VDD.n10 9.8005
R99 VDD.n3 VDD.n25 2.75725
R100 VDD.n32 VDD.n25 9.8005
R101 VDD.n32 VDD.n22 9.8005
R102 VDD.n5 VDD.n22 2.75725
R103 VDD.n33 VDD.n20 9.8005
R104 VDD.n36 VDD.n20 9.8005
R105 VDD.n36 VDD.n7 2.75725
R106 VDD.n37 VDD.n8 9.8005
R107 VDD.n4 VDD.n37 2.75725
R108 VDD.n15 VDD.n12 9.8005
R109 VDD.n14 VDD.n13 9.8005
R110 VDD.n39 VDD.n38 6.6505
R111 VDD VDD.n46 6.3005
R112 VDD.n45 VDD.n44 6.3005
R113 VDD.n6 VDD 1.77287
R114 VDD.n27 VDD.n10 6.3005
R115 VDD.n6 VDD.n10 2.75725
R116 VDD.n29 VDD.n28 6.3005
R117 VDD.n28 VDD.n3 2.75725
R118 VDD.n30 VDD.n25 6.3005
R119 VDD.n3 VDD 1.77287
R120 VDD.n32 VDD.n31 6.3005
R121 VDD VDD.n32 6.3005
R122 VDD.n26 VDD.n22 6.3005
R123 VDD VDD.n5 1.77287
R124 VDD.n34 VDD.n33 6.3005
R125 VDD.n33 VDD.n5 2.75725
R126 VDD.n35 VDD.n20 6.3005
R127 VDD.n20 VDD.n0 6.3005
R128 VDD.n36 VDD.t10 6.3005
R129 VDD.n0 VDD.n7 1.77287
R130 VDD.n21 VDD.n8 6.3005
R131 VDD.n7 VDD.n8 2.75725
R132 VDD.n37 VDD.n18 6.3005
R133 VDD.n4 VDD.n0 1.77287
R134 VDD.n40 VDD.n39 6.3005
R135 VDD.n39 VDD.n4 2.75725
R136 VDD.n41 VDD.n40 6.3005
R137 VDD.n2 VDD.n0 1.77287
R138 VDD.n38 VDD.n0 6.3005
R139 VDD.n13 VDD 6.3005
R140 VDD VDD.n14 6.3005
R141 VDD VDD.n15 6.3005
R142 VDD.n43 VDD.n12 6.3005
R143 VDD.n43 VDD.n42 6.3005
R144 VDD.n17 VDD.n1 5.4873
R145 VDD.n0 VDD.t11 3.97983
R146 VDD VDD.t1 3.20316
R147 VDD VDD.n24 2.9155
R148 VDD VDD.n23 2.91354
R149 VDD.n41 VDD.n1 2.82549
R150 VDD.n42 VDD.n16 2.82549
R151 VDD.n38 VDD.n19 2.75725
R152 VDD.n2 VDD.n19 5.514
R153 VDD.n15 VDD.n11 2.75725
R154 VDD.n14 VDD.n11 2.75725
R155 VDD.n16 VDD.n12 2.73055
R156 VDD.n13 VDD.n9 2.17736
R157 VDD.n46 VDD.n9 2.17736
R158 VDD VDD.n0 2.0885
R159 VDD.n43 VDD.n9 2.06282
R160 VDD.n0 VDD.n1 2.03587
R161 VDD.n16 VDD 2.03587
R162 VDD.n40 VDD.n17 1.77287
R163 VDD.n40 VDD.n19 1.77287
R164 VDD.n43 VDD.n11 1.77287
R165 VDD.n23 VDD.t7 1.06483
R166 VDD.n23 VDD.t9 1.06483
R167 VDD.n24 VDD.t3 1.06483
R168 VDD.n24 VDD.t5 1.06483
R169 VSS.n46 VSS.n45 513.399
R170 VSS.n27 VSS.n26 513.399
R171 VSS.n28 VSS.n27 513.399
R172 VSS.n32 VSS.n31 513.399
R173 VSS.n33 VSS.n20 513.399
R174 VSS.n36 VSS.n20 513.399
R175 VSS.n38 VSS.n37 513.399
R176 VSS.n38 VSS.n18 513.399
R177 VSS.n31 VSS.t2 495.063
R178 VSS.n37 VSS.t6 403.385
R179 VSS.t4 VSS.n32 320.875
R180 VSS.n26 VSS.t0 284.204
R181 VSS.n46 VSS.t0 229.196
R182 VSS.n43 VSS.n42 220.447
R183 VSS.n33 VSS.t4 192.525
R184 VSS.t6 VSS.n36 110.014
R185 VSS.n28 VSS.t2 18.3362
R186 VSS.n39 VSS.n19 10.8894
R187 VSS.n47 VSS.n17 10.8894
R188 VSS.n15 VSS.n5 2.57159
R189 VSS.n29 VSS.n25 10.1678
R190 VSS.n30 VSS.n16 9.83283
R191 VSS.n11 VSS.n16 2.52122
R192 VSS.n14 VSS.n3 2.49357
R193 VSS.n47 VSS.n9 9.52359
R194 VSS.n25 VSS 2.62691
R195 VSS.n35 VSS.n4 8.18122
R196 VSS.n12 VSS.n17 7.38939
R197 VSS.n6 VSS.n5 6.83183
R198 VSS.n29 VSS.n7 6.49448
R199 VSS VSS.n43 5.41963
R200 VSS.n42 VSS 5.41963
R201 VSS.n47 VSS.n46 5.2005
R202 VSS VSS.n47 5.2005
R203 VSS.n45 VSS.n17 5.2005
R204 VSS.n17 VSS 5.2005
R205 VSS.n27 VSS.n25 5.2005
R206 VSS.n26 VSS.n9 5.2005
R207 VSS.n9 VSS 5.2005
R208 VSS.n31 VSS.n30 5.2005
R209 VSS.n8 VSS 1.42649
R210 VSS.n29 VSS.n28 5.2005
R211 VSS VSS.n29 5.2005
R212 VSS.n32 VSS.n16 5.2005
R213 VSS VSS.n11 1.34089
R214 VSS.n5 VSS.n20 5.2005
R215 VSS VSS.n15 1.31571
R216 VSS.n34 VSS.n33 5.2005
R217 VSS.n34 VSS.n11 2.52122
R218 VSS.n37 VSS.n3 5.2005
R219 VSS VSS.n14 1.35472
R220 VSS.n36 VSS.n35 5.2005
R221 VSS.n35 VSS.n15 2.57159
R222 VSS.n19 VSS.n18 5.2005
R223 VSS.n13 VSS.n19 2.1609
R224 VSS.n39 VSS.n38 5.2005
R225 VSS.n14 VSS.n39 2.49357
R226 VSS.n40 VSS.n2 5.32092
R227 VSS.n13 VSS 1.52105
R228 VSS VSS.n12 5.2005
R229 VSS VSS.n1 1.27115
R230 VSS.n4 VSS.n21 4.5995
R231 VSS.n6 VSS.n22 4.5995
R232 VSS.n7 VSS.n23 4.5995
R233 VSS.n10 VSS.n24 4.5995
R234 VSS.n4 VSS.t7 4.4105
R235 VSS.n6 VSS.t5 4.4105
R236 VSS.n7 VSS.t3 4.4105
R237 VSS.n10 VSS.t1 4.4105
R238 VSS VSS.n10 1.59169
R239 VSS.n8 VSS.n7 0.861996
R240 VSS VSS.n6 3.1505
R241 VSS VSS.n4 3.1505
R242 VSS.n43 VSS.n0 2.66071
R243 VSS.n42 VSS.n41 2.66071
R244 VSS.n44 VSS.n12 2.66071
R245 VSS.n44 VSS.n1 5.32092
R246 VSS.n1 VSS.n0 5.32092
R247 VSS.n40 VSS.n13 4.82111
R248 VSS.n6 VSS.n34 2.80396
R249 VSS.n30 VSS.n8 1.42233
R250 VSS.n41 VSS.n2 5.32092
R251 VSS.n2 VSS 2.24271
R252 VSS.n4 VSS.n3 1.45456
R253 VSS.n41 VSS.n18 1.27115
R254 VSS.n40 VSS.n18 1.27115
R255 VSS.n45 VSS.n44 1.27115
R256 VSS.n45 VSS.n0 1.27115
R257 VSS.n10 VSS.n9 1.11721
C0 A Y 1.66703f
C1 A VDD 1.19014f
C2 Y VDD 1.38777f
C3 Y VSS 0.9483f
C4 A VSS 1.95671f
C5 VDD VSS 4.43398f
C6 VDD.n0 VSS 0.14009f
C7 VDD.n18 VSS 0.12128f
C8 VDD.n21 VSS 0.12128f
C9 VDD.t10 VSS 0.12128f
C10 VDD.n40 VSS 0.19274f
C11 VDD.n43 VSS 0.19274f
C12 VDD.n44 VSS 0.11261f
C13 A.n14 VSS 0.15966f
C14 A.n16 VSS 0.10227f
C15 A.n18 VSS 0.16225f
C16 A.n19 VSS 0.11004f
C17 A.n21 VSS 0.10949f
C18 A.n23 VSS 0.10356f
C19 A.n24 VSS 0.13061f
C20 A.n28 VSS 0.20131f
C21 A.n30 VSS 0.11104f
C22 Y.n0 VSS 0.54789f
C23 Y.n1 VSS 0.2478f
C24 Y.t1 VSS 0.156f
C25 Y.n2 VSS 0.11548f
C26 Y.n3 VSS 0.11548f
C27 Y.n4 VSS 0.11548f
C28 Y.n5 VSS 0.16287f
C29 Y.n6 VSS 0.17468f
C30 Y.n7 VSS 0.17468f
C31 Y.n8 VSS 0.17468f
C32 Y.n9 VSS 0.12386f
C33 Y.n10 VSS 0.12403f
C34 Y.n11 VSS 0.15567f
.ends
