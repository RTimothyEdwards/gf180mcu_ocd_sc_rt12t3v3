* NGSPICE file created from gf180mcu_ocd_sc_rt12t3v3__tbuf_1.ext - technology: gf180mcuD

.subckt gf180mcu_ocd_sc_rt12t3v3__tbuf_1 A EN Y VDD VSS
X0 EN_BAR.t0 EN.t3 VDD.t7 VDD.t6 pfet_03v3 ad=0.3341p pd=1.805u as=0.5654p ps=3.45u w=1.285u l=0.28u
X1 a_211_203r# A.t0 VSS.t6 VSS.t5 nfet_03v3 ad=0.3087p pd=2.01u as=3.0308p ps=16.66u w=1.02u l=0.28u
X2 VDD.t13 A.t1 a_211_203r# VDD.t12 pfet_03v3 ad=0.5654p pd=3.45u as=0.3341p ps=1.805u w=1.285u l=0.28u
X3 VDD.t1 a_211_203r# a_540_987.t0 VDD.t0 pfet_03v3 ad=0.3341p pd=1.805u as=0.5654p ps=3.45u w=1.285u l=0.28u
X4 Y.t1 EN.t1 a_629_203r# VSS.t2 nfet_03v3 ad=0.3087p pd=2.01u as=0.52065p ps=3.23u w=1.02u l=0.28u
X5 a_540_987.t2 EN_BAR.t3 Y.t0 VDD.t4 pfet_03v3 ad=0.5654p pd=3.45u as=0.3341p ps=1.805u w=1.285u l=0.28u
X6 a_540_987.t1 a_211_203r# VDD.t3 VDD.t2 pfet_03v3 ad=0.3341p pd=1.805u as=0.3341p ps=1.805u w=1.285u l=0.28u
X7 VDD.t9 EN.t2 EN_BAR.t1 VDD.t8 pfet_03v3 ad=0.5654p pd=3.45u as=0.3341p ps=1.805u w=1.285u l=0.28u
X8 a_211_203r# A.t2 VDD.t11 VDD.t10 pfet_03v3 ad=0.3341p pd=1.805u as=0.5654p ps=3.45u w=1.285u l=0.28u
X9 Y.t2 EN_BAR.t4 a_540_987.t3 VDD.t5 pfet_03v3 ad=0.3341p pd=1.805u as=0.3341p ps=1.805u w=1.285u l=0.28u
X10 EN_BAR.t2 EN.t0 VSS.t4 VSS.t3 nfet_03v3 ad=0.3087p pd=2.01u as=3.0308p ps=16.66u w=1.02u l=0.28u
X11 a_629_203r# a_211_203r# VSS.t1 VSS.t0 nfet_03v3 ad=0.3087p pd=2.01u as=3.0308p ps=16.66u w=1.02u l=0.28u
R0 Y Y.t1 6.54996
R1 Y Y.n0 5.44018
R2 Y.t1 Y.n1 3.1489
R3 Y.n0 Y.t0 1.41684
R4 Y.n0 Y.t2 1.41684
R5 EN.n0 EN.t3 39.6951
R6 EN.n0 EN.t2 38.0951
R7 EN EN.t1 13.7735
R8 EN EN.n0 4.33762
R9 EN EN.t0 11.3134
R10 A.n5 A.n2 46.93
R11 A.n1 A.t1 40.165
R12 A.n4 A.n3 39.4102
R13 A.n1 A.t2 35.5011
R14 A.t0 A.n2 7.15908
R15 A.n0 A.n5 35.8623
R16 A A.n1 4.6815
R17 A.n4 A.t0 3.70097
R18 A.n5 A.n4 3.07611
R19 A.n3 A.n0 4.15115
R20 A A.n0 3.25316
R21 A.n3 A.n2 2.8536
R22 VDD.n52 VDD.n51 250.999
R23 VDD.n54 VDD.n53 137.088
R24 VDD.n34 VDD.n32 137.088
R25 VDD.n36 VDD.n35 137.088
R26 VDD.n39 VDD.n28 137.088
R27 VDD.n41 VDD.n27 137.088
R28 VDD.n45 VDD.n44 137.088
R29 VDD.n46 VDD.n25 137.088
R30 VDD.n50 VDD.n21 137.088
R31 VDD.n54 VDD.t10 117.504
R32 VDD.n36 VDD.t0 117.504
R33 VDD.n44 VDD.t4 117.504
R34 VDD.t8 VDD.n21 117.504
R35 VDD.n35 VDD.t12 97.9197
R36 VDD.n40 VDD.t2 97.9197
R37 VDD.t5 VDD.n40 97.9197
R38 VDD.t6 VDD.n45 97.9197
R39 VDD.t12 VDD.n34 39.1682
R40 VDD.t2 VDD.n39 39.1682
R41 VDD.n41 VDD.t5 39.1682
R42 VDD.n46 VDD.t6 39.1682
R43 VDD.n32 VDD.t10 19.5843
R44 VDD.t0 VDD.n28 19.5843
R45 VDD.n27 VDD.t4 19.5843
R46 VDD.n25 VDD.t8 19.5843
R47 VDD.n2 VDD.n20 5.514
R48 VDD.n56 VDD.n55 9.8005
R49 VDD.n55 VDD.n10 2.75725
R50 VDD.n33 VDD.n13 9.8005
R51 VDD.n5 VDD.n31 2.75725
R52 VDD.n37 VDD.n31 9.8005
R53 VDD.n37 VDD.n29 9.8005
R54 VDD.n11 VDD.n29 2.75725
R55 VDD.n38 VDD.n26 9.8005
R56 VDD.n42 VDD.n26 9.8005
R57 VDD.n7 VDD.n6 2.75725
R58 VDD.n43 VDD.n6 9.8005
R59 VDD.n8 VDD.n24 2.75725
R60 VDD.n47 VDD.n24 9.8005
R61 VDD.n47 VDD.n23 9.8005
R62 VDD.n9 VDD.n23 2.75725
R63 VDD.n49 VDD.n48 9.8005
R64 VDD.n18 VDD.n15 9.8005
R65 VDD.n17 VDD.n16 9.8005
R66 VDD.n4 VDD.n22 4.93411
R67 VDD VDD.n56 6.3005
R68 VDD.n55 VDD.n54 6.3005
R69 VDD.n10 VDD 1.77287
R70 VDD.n32 VDD.n13 6.3005
R71 VDD.n10 VDD.n13 2.75725
R72 VDD.n34 VDD.n33 6.3005
R73 VDD.n33 VDD.n5 2.75725
R74 VDD.n35 VDD.n31 6.3005
R75 VDD.n5 VDD 1.77287
R76 VDD.n37 VDD.n36 6.3005
R77 VDD VDD.n37 6.3005
R78 VDD.n29 VDD.n28 6.3005
R79 VDD VDD.n11 1.77287
R80 VDD.n39 VDD.n38 6.3005
R81 VDD.n38 VDD.n11 2.75725
R82 VDD.n40 VDD.n26 6.3005
R83 VDD.n26 VDD 6.3005
R84 VDD.n42 VDD.n41 6.3005
R85 VDD.n7 VDD.n42 2.75725
R86 VDD.n27 VDD.n6 6.3005
R87 VDD VDD.n7 1.77287
R88 VDD.n44 VDD.n43 6.3005
R89 VDD.n43 VDD.n8 2.75725
R90 VDD.n45 VDD.n24 6.3005
R91 VDD.n8 VDD 1.77287
R92 VDD.n47 VDD.n46 6.3005
R93 VDD VDD.n47 6.3005
R94 VDD.n25 VDD.n23 6.3005
R95 VDD VDD.n9 1.77287
R96 VDD.n48 VDD.n21 6.3005
R97 VDD.n48 VDD.n9 2.75725
R98 VDD.n50 VDD.n49 6.3005
R99 VDD.n49 VDD.n4 2.17736
R100 VDD.n51 VDD.n50 6.3005
R101 VDD.n2 VDD.n0 1.77287
R102 VDD.n4 VDD.n0 2.06282
R103 VDD.n16 VDD 6.3005
R104 VDD.n3 VDD.n17 6.3005
R105 VDD.n3 VDD.n18 6.3005
R106 VDD.n53 VDD.n15 6.3005
R107 VDD.n53 VDD.n52 6.3005
R108 VDD.n20 VDD.n1 5.4873
R109 VDD VDD.n30 5.42746
R110 VDD VDD.t9 4.32793
R111 VDD VDD.t13 4.32793
R112 VDD VDD.t11 4.32597
R113 VDD VDD.t7 4.32597
R114 VDD.n51 VDD.n1 2.82549
R115 VDD.n52 VDD.n19 2.82549
R116 VDD.n2 VDD.n22 5.514
R117 VDD.n18 VDD.n14 2.75725
R118 VDD.n17 VDD.n14 2.75725
R119 VDD.n19 VDD.n15 2.73055
R120 VDD.n16 VDD.n12 2.17736
R121 VDD.n56 VDD.n12 2.17736
R122 VDD.n53 VDD.n12 2.06282
R123 VDD.n0 VDD.n1 2.03587
R124 VDD.n19 VDD.n3 2.03587
R125 VDD.n50 VDD.n20 1.77287
R126 VDD.n50 VDD.n22 1.77287
R127 VDD.n53 VDD.n14 1.77287
R128 VDD.n30 VDD.t1 1.41684
R129 VDD.n30 VDD.t3 1.41684
R130 VDD VDD.n0 1.2125
R131 VDD.n3 VDD 1.2125
R132 VSS.n56 VSS.n55 513.399
R133 VSS.n32 VSS.n31 513.399
R134 VSS.n33 VSS.n32 513.399
R135 VSS.n33 VSS.n30 513.399
R136 VSS.n37 VSS.n36 513.399
R137 VSS.n37 VSS.n27 513.399
R138 VSS.n41 VSS.n40 513.399
R139 VSS.n42 VSS.n41 513.399
R140 VSS.n42 VSS.n24 513.399
R141 VSS.n46 VSS.n45 513.399
R142 VSS.n47 VSS.n46 513.399
R143 VSS.n47 VSS.n20 513.399
R144 VSS.n27 VSS.t2 504.231
R145 VSS.n56 VSS.t5 398.801
R146 VSS.n53 VSS.n52 291.721
R147 VSS.n30 VSS.t0 261.284
R148 VSS.n24 VSS.t3 261.284
R149 VSS.n36 VSS.t0 252.117
R150 VSS.n45 VSS.t3 252.117
R151 VSS.n31 VSS.t5 114.599
R152 VSS.n48 VSS.n11 2.66071
R153 VSS.n39 VSS.n25 10.8894
R154 VSS.n39 VSS.n23 10.8894
R155 VSS.n43 VSS.n10 2.66071
R156 VSS.n43 VSS.n15 10.8894
R157 VSS.n34 VSS.n16 10.8894
R158 VSS.n57 VSS.n19 10.8894
R159 VSS.n48 VSS.n17 10.593
R160 VSS.n38 VSS.n12 2.62485
R161 VSS.n34 VSS.n14 2.57652
R162 VSS.n57 VSS.n18 10.0003
R163 VSS.n44 VSS.n13 2.4988
R164 VSS.n35 VSS.n8 2.4988
R165 VSS.n40 VSS.t2 9.16834
R166 VSS.n7 VSS.n17 2.53355
R167 VSS.n38 VSS.n3 7.92821
R168 VSS.n9 VSS.n19 7.38939
R169 VSS.n49 VSS.n21 7.38939
R170 VSS VSS.n53 5.41963
R171 VSS.n52 VSS 5.41963
R172 VSS.n29 VSS.n5 5.39809
R173 VSS.n57 VSS.n56 5.2005
R174 VSS VSS.n57 5.2005
R175 VSS.n55 VSS.n19 5.2005
R176 VSS.n19 VSS 5.2005
R177 VSS.n32 VSS.n29 5.2005
R178 VSS.n29 VSS.n14 2.57652
R179 VSS.n31 VSS.n18 5.2005
R180 VSS.n18 VSS.n4 1.67338
R181 VSS.n30 VSS.n16 5.2005
R182 VSS.n8 VSS.n16 2.4988
R183 VSS.n34 VSS.n33 5.2005
R184 VSS VSS.n14 1.31324
R185 VSS.n38 VSS.n37 5.2005
R186 VSS VSS.n12 1.28908
R187 VSS.n36 VSS.n35 5.2005
R188 VSS.n8 VSS 1.3521
R189 VSS.n24 VSS.n15 5.2005
R190 VSS.n13 VSS.n15 2.4988
R191 VSS.n43 VSS.n42 5.2005
R192 VSS VSS.n10 1.27115
R193 VSS.n41 VSS.n23 5.2005
R194 VSS.n23 VSS.n10 2.66071
R195 VSS.n40 VSS.n39 5.2005
R196 VSS.n39 VSS 5.2005
R197 VSS.n27 VSS.n25 5.2005
R198 VSS.n12 VSS.n25 2.62485
R199 VSS.n46 VSS.n17 5.2005
R200 VSS VSS.n7 1.00728
R201 VSS.n45 VSS.n44 5.2005
R202 VSS.n13 VSS 1.3521
R203 VSS.n21 VSS.n20 5.2005
R204 VSS.n11 VSS.n21 2.66071
R205 VSS.n48 VSS.n47 5.2005
R206 VSS VSS.n11 1.27115
R207 VSS.n2 VSS 1.27115
R208 VSS.n50 VSS.n2 5.32092
R209 VSS.n49 VSS 5.2005
R210 VSS VSS.n9 5.2005
R211 VSS VSS.n1 1.27115
R212 VSS.n6 VSS.t4 4.5995
R213 VSS.n3 VSS.n26 4.5995
R214 VSS.n5 VSS.n28 4.5995
R215 VSS.n6 VSS.n22 4.4735
R216 VSS.n3 VSS.t1 4.4105
R217 VSS.n5 VSS.t6 4.4105
R218 VSS.n5 VSS.n4 1.07486
R219 VSS VSS.n4 1.3804
R220 VSS.n3 VSS 3.1505
R221 VSS.n7 VSS.n6 1.53514
R222 VSS.n53 VSS.n0 2.66071
R223 VSS.n52 VSS.n51 2.66071
R224 VSS.n54 VSS.n9 2.66071
R225 VSS.n54 VSS.n1 5.32092
R226 VSS.n1 VSS.n0 5.32092
R227 VSS.n50 VSS.n49 2.66071
R228 VSS.n51 VSS.n2 5.32092
R229 VSS.n35 VSS.n3 1.70757
R230 VSS.n44 VSS.n6 1.64457
R231 VSS.n51 VSS.n20 1.27115
R232 VSS.n50 VSS.n20 1.27115
R233 VSS.n55 VSS.n54 1.27115
R234 VSS.n55 VSS.n0 1.27115
R235 a_540_987.t0 a_540_987.n1 4.91293
R236 a_540_987.n1 a_540_987.t2 4.89923
R237 a_540_987.n1 a_540_987.n0 2.6005
R238 a_540_987.n0 a_540_987.t3 1.41684
R239 a_540_987.n0 a_540_987.t1 1.41684
R240 EN_BAR.n0 EN_BAR.t4 41.4913
R241 EN_BAR.n0 EN_BAR.t3 19.4862
R242 EN_BAR.n2 EN_BAR.n0 12.639
R243 EN_BAR.t2 EN_BAR.n3 3.32853
R244 EN_BAR.n2 EN_BAR.n1 2.90767
R245 EN_BAR.n1 EN_BAR.t0 1.41684
R246 EN_BAR.n1 EN_BAR.t1 1.41684
R247 EN_BAR EN_BAR.t2 7.80377
R248 EN_BAR EN_BAR.n2 1.04415
C0 VDD A 0.51939f
C1 Y a_629_203r# 0.12927f
C2 EN_BAR Y 0.11075f
C3 a_629_203r# a_211_203r# 0.16221f
C4 EN EN_BAR 0.9055f
C5 EN Y 0.16339f
C6 VDD EN_BAR 1.05365f
C7 VDD a_211_203r# 0.79408f
C8 VDD EN 0.4664f
C9 A a_211_203r# 0.5176f
C10 Y VSS 0.46853f
C11 EN VSS 1.53914f
C12 A VSS 0.81831f
C13 VDD VSS 5.87327f
C14 a_629_203r# VSS 0.12254f
C15 EN_BAR VSS 0.89454f
C16 a_211_203r# VSS 0.61314f
C17 EN_BAR.t2 VSS 0.2536f
C18 EN_BAR.t4 VSS 0.13896f
C19 EN_BAR.n0 VSS 0.19893f
C20 EN_BAR.n1 VSS 0.14829f
C21 EN_BAR.n2 VSS 0.54586f
C22 EN_BAR.n3 VSS 0.25764f
C23 a_540_987.t2 VSS 0.26167f
C24 a_540_987.n0 VSS 0.16651f
C25 a_540_987.n1 VSS 0.74239f
C26 a_540_987.t0 VSS 0.26272f
C27 VDD.n21 VSS 0.1394f
C28 VDD.n35 VSS 0.12867f
C29 VDD.n36 VSS 0.1394f
C30 VDD.n40 VSS 0.10723f
C31 VDD.n44 VSS 0.1394f
C32 VDD.n45 VSS 0.12867f
C33 VDD.n50 VSS 0.22518f
C34 VDD.n53 VSS 0.25199f
C35 VDD.n54 VSS 0.1394f
C36 A.n0 VSS 0.22991f
C37 A.n1 VSS 0.14921f
C38 A.n5 VSS 0.14947f
C39 EN.n0 VSS 0.12631f
C40 EN.t1 VSS 0.36348f
C41 EN.t0 VSS 0.31327f
C42 Y.t1 VSS 0.13114f
.ends
