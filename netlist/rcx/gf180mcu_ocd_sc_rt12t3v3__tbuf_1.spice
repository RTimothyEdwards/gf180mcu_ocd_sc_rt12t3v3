* NGSPICE file created from gf180mcu_ocd_sc_rt12t3v3__tbuf_1.ext - technology: gf180mcuD

.subckt gf180mcu_ocd_sc_rt12t3v3__tbuf_1 A EN Y VDD VSS
X0 EN_BAR.t1 EN.t3 VDD.t11 VDD.t10 pfet_03v3 ad=0.3341p pd=1.805u as=0.5654p ps=3.45u w=1.285u l=0.28u
X1 a_211_203r# A.t0 VSS.t1 VSS.t0 nfet_03v3 ad=0.3087p pd=2.01u as=3.0308p ps=16.66u w=1.02u l=0.28u
X2 VDD.t5 A.t1 a_211_203r# VDD.t4 pfet_03v3 ad=0.5654p pd=3.45u as=0.3341p ps=1.805u w=1.285u l=0.28u
X3 VDD.t7 a_211_203r# a_540_987.t2 VDD.t6 pfet_03v3 ad=0.3341p pd=1.805u as=0.5654p ps=3.45u w=1.285u l=0.28u
X4 Y.t2 EN.t1 a_629_203r# VSS.t4 nfet_03v3 ad=0.3087p pd=2.01u as=0.52065p ps=3.23u w=1.02u l=0.28u
X5 a_540_987.t1 EN_BAR.t3 Y.t1 VDD.t1 pfet_03v3 ad=0.5654p pd=3.45u as=0.3341p ps=1.805u w=1.285u l=0.28u
X6 a_540_987.t3 a_211_203r# VDD.t9 VDD.t8 pfet_03v3 ad=0.3341p pd=1.805u as=0.3341p ps=1.805u w=1.285u l=0.28u
X7 VDD.t13 EN.t2 EN_BAR.t2 VDD.t12 pfet_03v3 ad=0.5654p pd=3.45u as=0.3341p ps=1.805u w=1.285u l=0.28u
X8 a_211_203r# A.t2 VDD.t3 VDD.t2 pfet_03v3 ad=0.3341p pd=1.805u as=0.5654p ps=3.45u w=1.285u l=0.28u
X9 Y.t0 EN_BAR.t4 a_540_987.t0 VDD.t0 pfet_03v3 ad=0.3341p pd=1.805u as=0.3341p ps=1.805u w=1.285u l=0.28u
X10 EN_BAR.t0 EN.t0 VSS.t6 VSS.t5 nfet_03v3 ad=0.3087p pd=2.01u as=3.0308p ps=16.66u w=1.02u l=0.28u
X11 a_629_203r# a_211_203r# VSS.t3 VSS.t2 nfet_03v3 ad=0.3087p pd=2.01u as=3.0308p ps=16.66u w=1.02u l=0.28u
R0 Y.n9 Y.n5 88.7005
R1 Y.n12 Y.n2 85.0505
R2 Y.n5 Y.n2 47.2505
R3 Y.n13 Y.n12 47.2505
R4 Y.n6 Y.n4 17.0759
R5 Y.n9 Y.n8 15.5491
R6 Y.n10 Y.n9 11.0809
R7 Y.n13 Y.n11 10.4505
R8 Y.n11 Y.n4 8.32713
R9 Y.n14 Y.t2 6.40912
R10 Y Y.n14 6.38463
R11 Y.n11 Y.n10 5.73172
R12 Y Y.n1 5.44018
R13 Y.n6 Y.n0 5.06743
R14 Y.n10 Y.n3 3.1505
R15 Y.n12 Y.n3 3.1505
R16 Y.t2 Y.n13 3.1505
R17 Y.t2 Y.n0 0.206238
R18 Y.t2 Y.n4 2.1221
R19 Y.t2 Y.n3 1.85912
R20 Y.n5 Y.n3 1.7505
R21 Y.n14 Y.n2 1.62981
R22 Y.n0 Y.n2 3.88957
R23 Y.n1 Y.t0 1.41684
R24 Y.n1 Y.t1 1.41684
R25 Y.n8 Y.n7 1.32827
R26 Y.n8 Y.n6 1.16236
R27 EN.n0 EN.t3 39.6951
R28 EN.n0 EN.t2 38.0951
R29 EN EN.n0 4.33762
R30 EN EN.t0 8.58455
R31 EN EN.t1 12.1935
R32 A.n4 A.n3 48.4292
R33 A.n0 A.t1 40.165
R34 A.n0 A.t2 35.5011
R35 A.n5 A.n4 31.4116
R36 A.n2 A.n1 14.1338
R37 A.n4 A.n2 5.32637
R38 A A.n0 4.6815
R39 A A.n5 3.24257
R40 A.n5 A.n1 3.16362
R41 A.n3 A.n1 2.16571
R42 A.n3 A.t0 2.04207
R43 A.t0 A.n2 1.38306
R44 VDD.n52 VDD.n51 250.999
R45 VDD.n54 VDD.n53 137.088
R46 VDD.n34 VDD.n32 137.088
R47 VDD.n36 VDD.n35 137.088
R48 VDD.n39 VDD.n28 137.088
R49 VDD.n41 VDD.n27 137.088
R50 VDD.n45 VDD.n44 137.088
R51 VDD.n46 VDD.n25 137.088
R52 VDD.n50 VDD.n21 137.088
R53 VDD.n54 VDD.t2 117.504
R54 VDD.n36 VDD.t6 117.504
R55 VDD.n44 VDD.t1 117.504
R56 VDD.t12 VDD.n21 117.504
R57 VDD.n35 VDD.t4 97.9197
R58 VDD.n40 VDD.t8 97.9197
R59 VDD.t0 VDD.n40 97.9197
R60 VDD.t10 VDD.n45 97.9197
R61 VDD.t4 VDD.n34 39.1682
R62 VDD.t8 VDD.n39 39.1682
R63 VDD.n41 VDD.t0 39.1682
R64 VDD.n46 VDD.t10 39.1682
R65 VDD.n32 VDD.t2 19.5843
R66 VDD.t6 VDD.n28 19.5843
R67 VDD.n27 VDD.t1 19.5843
R68 VDD.n25 VDD.t12 19.5843
R69 VDD.n2 VDD.n20 5.514
R70 VDD.n56 VDD.n55 9.8005
R71 VDD.n55 VDD.n10 2.75725
R72 VDD.n33 VDD.n13 9.8005
R73 VDD.n5 VDD.n31 2.75725
R74 VDD.n37 VDD.n31 9.8005
R75 VDD.n37 VDD.n29 9.8005
R76 VDD.n11 VDD.n29 2.75725
R77 VDD.n38 VDD.n26 9.8005
R78 VDD.n42 VDD.n26 9.8005
R79 VDD.n7 VDD.n6 2.75725
R80 VDD.n43 VDD.n6 9.8005
R81 VDD.n8 VDD.n24 2.75725
R82 VDD.n47 VDD.n24 9.8005
R83 VDD.n47 VDD.n23 9.8005
R84 VDD.n9 VDD.n23 2.75725
R85 VDD.n49 VDD.n48 9.8005
R86 VDD.n18 VDD.n15 9.8005
R87 VDD.n17 VDD.n16 9.8005
R88 VDD.n4 VDD.n22 4.93411
R89 VDD VDD.n56 6.3005
R90 VDD.n55 VDD.n54 6.3005
R91 VDD.n10 VDD 1.77287
R92 VDD.n32 VDD.n13 6.3005
R93 VDD.n10 VDD.n13 2.75725
R94 VDD.n34 VDD.n33 6.3005
R95 VDD.n33 VDD.n5 2.75725
R96 VDD.n35 VDD.n31 6.3005
R97 VDD.n5 VDD 1.77287
R98 VDD.n37 VDD.n36 6.3005
R99 VDD VDD.n37 6.3005
R100 VDD.n29 VDD.n28 6.3005
R101 VDD VDD.n11 1.77287
R102 VDD.n39 VDD.n38 6.3005
R103 VDD.n38 VDD.n11 2.75725
R104 VDD.n40 VDD.n26 6.3005
R105 VDD.n26 VDD 6.3005
R106 VDD.n42 VDD.n41 6.3005
R107 VDD.n7 VDD.n42 2.75725
R108 VDD.n27 VDD.n6 6.3005
R109 VDD VDD.n7 1.77287
R110 VDD.n44 VDD.n43 6.3005
R111 VDD.n43 VDD.n8 2.75725
R112 VDD.n45 VDD.n24 6.3005
R113 VDD.n8 VDD 1.77287
R114 VDD.n47 VDD.n46 6.3005
R115 VDD VDD.n47 6.3005
R116 VDD.n25 VDD.n23 6.3005
R117 VDD VDD.n9 1.77287
R118 VDD.n48 VDD.n21 6.3005
R119 VDD.n48 VDD.n9 2.75725
R120 VDD.n50 VDD.n49 6.3005
R121 VDD.n49 VDD.n4 2.17736
R122 VDD.n51 VDD.n50 6.3005
R123 VDD.n2 VDD.n0 1.77287
R124 VDD.n4 VDD.n0 2.06282
R125 VDD.n16 VDD 6.3005
R126 VDD.n3 VDD.n17 6.3005
R127 VDD.n3 VDD.n18 6.3005
R128 VDD.n53 VDD.n15 6.3005
R129 VDD.n53 VDD.n52 6.3005
R130 VDD.n20 VDD.n1 5.4873
R131 VDD VDD.n30 5.42746
R132 VDD VDD.t13 4.32793
R133 VDD VDD.t5 4.32793
R134 VDD VDD.t3 4.32597
R135 VDD VDD.t11 4.32597
R136 VDD.n51 VDD.n1 2.82549
R137 VDD.n52 VDD.n19 2.82549
R138 VDD.n2 VDD.n22 5.514
R139 VDD.n18 VDD.n14 2.75725
R140 VDD.n17 VDD.n14 2.75725
R141 VDD.n19 VDD.n15 2.73055
R142 VDD.n16 VDD.n12 2.17736
R143 VDD.n56 VDD.n12 2.17736
R144 VDD.n53 VDD.n12 2.06282
R145 VDD.n0 VDD.n1 2.03587
R146 VDD.n19 VDD.n3 2.03587
R147 VDD.n50 VDD.n20 1.77287
R148 VDD.n50 VDD.n22 1.77287
R149 VDD.n53 VDD.n14 1.77287
R150 VDD.n30 VDD.t7 1.41684
R151 VDD.n30 VDD.t9 1.41684
R152 VDD VDD.n0 1.2125
R153 VDD.n3 VDD 1.2125
R154 VSS.n56 VSS.n55 513.399
R155 VSS.n32 VSS.n31 513.399
R156 VSS.n33 VSS.n32 513.399
R157 VSS.n33 VSS.n30 513.399
R158 VSS.n37 VSS.n36 513.399
R159 VSS.n37 VSS.n27 513.399
R160 VSS.n41 VSS.n40 513.399
R161 VSS.n42 VSS.n41 513.399
R162 VSS.n42 VSS.n24 513.399
R163 VSS.n46 VSS.n45 513.399
R164 VSS.n47 VSS.n46 513.399
R165 VSS.n47 VSS.n20 513.399
R166 VSS.n27 VSS.t4 504.231
R167 VSS.n56 VSS.t0 398.801
R168 VSS.n53 VSS.n52 291.721
R169 VSS.n30 VSS.t2 261.284
R170 VSS.n24 VSS.t5 261.284
R171 VSS.n36 VSS.t2 252.117
R172 VSS.n45 VSS.t5 252.117
R173 VSS.n31 VSS.t0 114.599
R174 VSS.n48 VSS.n11 2.66071
R175 VSS.n39 VSS.n25 10.8894
R176 VSS.n39 VSS.n23 10.8894
R177 VSS.n43 VSS.n10 2.66071
R178 VSS.n43 VSS.n15 10.8894
R179 VSS.n34 VSS.n16 10.8894
R180 VSS.n57 VSS.n19 10.8894
R181 VSS.n48 VSS.n17 10.593
R182 VSS.n38 VSS.n12 2.62485
R183 VSS.n34 VSS.n14 2.57652
R184 VSS.n57 VSS.n18 10.0003
R185 VSS.n44 VSS.n13 2.4988
R186 VSS.n8 VSS.n16 2.4988
R187 VSS.n40 VSS.t4 9.16834
R188 VSS.n7 VSS.n17 2.53355
R189 VSS.n38 VSS.n3 7.92821
R190 VSS.n9 VSS.n19 7.38939
R191 VSS.n49 VSS.n21 7.38939
R192 VSS VSS.n53 5.41963
R193 VSS.n52 VSS 5.41963
R194 VSS.n29 VSS.n4 5.39809
R195 VSS.n57 VSS.n56 5.2005
R196 VSS VSS.n57 5.2005
R197 VSS.n55 VSS.n19 5.2005
R198 VSS.n19 VSS 5.2005
R199 VSS.n32 VSS.n29 5.2005
R200 VSS.n29 VSS.n14 2.57652
R201 VSS.n31 VSS.n18 5.2005
R202 VSS.n5 VSS 1.32216
R203 VSS.n30 VSS.n16 5.2005
R204 VSS VSS.n8 1.3521
R205 VSS.n34 VSS.n33 5.2005
R206 VSS VSS.n14 1.31324
R207 VSS.n38 VSS.n37 5.2005
R208 VSS VSS.n12 1.28908
R209 VSS.n36 VSS.n35 5.2005
R210 VSS.n35 VSS.n8 2.4988
R211 VSS.n24 VSS.n15 5.2005
R212 VSS.n13 VSS.n15 2.4988
R213 VSS.n43 VSS.n42 5.2005
R214 VSS VSS.n10 1.27115
R215 VSS.n41 VSS.n23 5.2005
R216 VSS.n23 VSS.n10 2.66071
R217 VSS.n40 VSS.n39 5.2005
R218 VSS.n39 VSS 5.2005
R219 VSS.n27 VSS.n25 5.2005
R220 VSS.n12 VSS.n25 2.62485
R221 VSS.n46 VSS.n17 5.2005
R222 VSS VSS.n7 1.00728
R223 VSS.n45 VSS.n44 5.2005
R224 VSS.n13 VSS 1.3521
R225 VSS.n21 VSS.n20 5.2005
R226 VSS.n11 VSS.n21 2.66071
R227 VSS.n48 VSS.n47 5.2005
R228 VSS VSS.n11 1.27115
R229 VSS.n2 VSS 1.27115
R230 VSS.n50 VSS.n2 5.32092
R231 VSS.n49 VSS 5.2005
R232 VSS VSS.n9 5.2005
R233 VSS VSS.n1 1.27115
R234 VSS.n6 VSS.t6 4.5995
R235 VSS.n3 VSS.t3 4.4105
R236 VSS.n4 VSS.t1 4.4105
R237 VSS.n5 VSS.n18 1.69888
R238 VSS.n5 VSS.n4 1.02952
R239 VSS.n3 VSS 3.1505
R240 VSS.n4 VSS.n28 2.9615
R241 VSS.n7 VSS.n6 1.53514
R242 VSS.n3 VSS.n26 2.7725
R243 VSS.n53 VSS.n0 2.66071
R244 VSS.n52 VSS.n51 2.66071
R245 VSS.n54 VSS.n9 2.66071
R246 VSS.n54 VSS.n1 5.32092
R247 VSS.n1 VSS.n0 5.32092
R248 VSS.n50 VSS.n49 2.66071
R249 VSS.n51 VSS.n2 5.32092
R250 VSS.n6 VSS.n22 2.6465
R251 VSS.n35 VSS.n3 1.70757
R252 VSS.n44 VSS.n6 1.64457
R253 VSS.n51 VSS.n20 1.27115
R254 VSS.n50 VSS.n20 1.27115
R255 VSS.n55 VSS.n54 1.27115
R256 VSS.n55 VSS.n0 1.27115
R257 a_540_987.t2 a_540_987.n1 4.91293
R258 a_540_987.n1 a_540_987.t1 4.89923
R259 a_540_987.n1 a_540_987.n0 2.6005
R260 a_540_987.n0 a_540_987.t0 1.41684
R261 a_540_987.n0 a_540_987.t3 1.41684
R262 EN_BAR.n8 EN_BAR.t0 50.9005
R263 EN_BAR.n5 EN_BAR.t4 41.4913
R264 EN_BAR.n2 EN_BAR.n9 32.5888
R265 EN_BAR.n5 EN_BAR.t3 19.4862
R266 EN_BAR.n9 EN_BAR.n8 16.9387
R267 EN_BAR.n7 EN_BAR.n5 12.639
R268 EN_BAR.n8 EN_BAR.n0 11.9058
R269 EN_BAR EN_BAR.n3 7.10132
R270 EN_BAR.n3 EN_BAR.n0 3.31861
R271 EN_BAR.n9 EN_BAR.n4 3.6505
R272 EN_BAR.n7 EN_BAR.n6 2.90767
R273 EN_BAR.n2 EN_BAR.n0 0.0474974
R274 EN_BAR.n1 EN_BAR.t0 0.459182
R275 EN_BAR.n1 EN_BAR.n4 0.825727
R276 EN_BAR.n6 EN_BAR.t1 1.41684
R277 EN_BAR.n6 EN_BAR.t2 1.41684
R278 EN_BAR EN_BAR.n7 1.04415
R279 EN_BAR.n3 EN_BAR.t0 5.88322
R280 EN_BAR.n3 EN_BAR.n4 1.7588
R281 EN_BAR.n2 EN_BAR.n1 1.57306
C0 Y a_629_203r# 0.12927f
C1 A VDD 0.51939f
C2 EN EN_BAR 0.9055f
C3 a_211_203r# VDD 0.79408f
C4 Y EN 0.16339f
C5 Y EN_BAR 0.11075f
C6 EN VDD 0.4664f
C7 EN_BAR VDD 1.05365f
C8 A a_211_203r# 0.5176f
C9 a_211_203r# a_629_203r# 0.16221f
C10 Y VSS 0.4018f
C11 EN VSS 1.46008f
C12 A VSS 0.86871f
C13 VDD VSS 5.87327f
C14 a_629_203r# VSS 0.32487f
C15 EN_BAR VSS 0.86212f
C16 EN_BAR.n2 VSS 0.11861f
C17 EN_BAR.t0 VSS 0.19954f
C18 EN_BAR.n5 VSS 0.18559f
C19 EN_BAR.t2 VSS 0.11084f
C20 EN_BAR.t1 VSS 0.11171f
C21 EN_BAR.n6 VSS 0.13835f
C22 EN_BAR.n7 VSS 0.50928f
C23 EN_BAR.n8 VSS 0.10994f
C24 EN_BAR.n9 VSS 0.16139f
C25 a_540_987.t1 VSS 0.32882f
C26 a_540_987.t0 VSS 0.17191f
C27 a_540_987.n0 VSS 0.16651f
C28 a_540_987.n1 VSS 0.74239f
C29 a_540_987.t2 VSS 0.59542f
C30 VSS.t6 VSS 0.17493f
C31 VDD.n21 VSS 0.1394f
C32 VDD.t7 VSS 0.34366f
C33 VDD.n35 VSS 0.12867f
C34 VDD.n36 VSS 0.1394f
C35 VDD.n40 VSS 0.10723f
C36 VDD.n44 VSS 0.1394f
C37 VDD.n45 VSS 0.12867f
C38 VDD.n50 VSS 0.22518f
C39 VDD.n53 VSS 0.25199f
C40 VDD.n54 VSS 0.1394f
C41 A.n0 VSS 0.14236f
C42 A.n4 VSS 0.1188f
C43 A.n5 VSS 0.20498f
C44 EN.n0 VSS 0.12779f
C45 Y.t2 VSS 0.20468f
C46 Y.t1 VSS 0.1058f
C47 Y.t0 VSS 0.1273f
.ends
