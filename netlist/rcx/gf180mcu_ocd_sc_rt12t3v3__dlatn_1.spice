* NGSPICE file created from gf180mcu_ocd_sc_rt12t3v3__dlatn_1.ext - technology: gf180mcuD

.subckt gf180mcu_ocd_sc_rt12t3v3__dlatn_1 D CLK Q VDD VSS
X0 a_828_987.t0 CLKb.t4 in2.t4 VDD.t6 pfet_03v3 ad=0.5654p pd=3.45u as=0.3341p ps=1.805u w=1.285u l=0.28u
X1 out2 in2.t8 VDD.t15 VDD.t14 pfet_03v3 ad=0.3341p pd=1.805u as=0.5654p ps=3.45u w=1.285u l=0.28u
X2 Q.t1 a_2849_203r# VSS.t7 VSS.t6 nfet_03v3 ad=0.3087p pd=2.01u as=2.81442p ps=15.045u w=1.02u l=0.28u
X3 VDD.t23 out2 a_2849_203r# VDD.t22 pfet_03v3 ad=0.3341p pd=1.805u as=0.3341p ps=1.805u w=1.285u l=0.28u
X4 CLKN CLK.t2 VDD.t29 VDD.t28 pfet_03v3 ad=0.3341p pd=1.805u as=6.973p ps=42.83u w=1.285u l=0.28u
X5 VDD.t3 CLKN CLKb.t1 VDD.t2 pfet_03v3 ad=0.5654p pd=3.45u as=0.3341p ps=1.805u w=1.285u l=0.28u
X6 VDD.t25 D.t2 a_828_987.t2 VDD.t24 pfet_03v3 ad=0.3341p pd=1.805u as=0.5654p ps=3.45u w=1.285u l=0.28u
X7 VDD.t17 out2 a_2044_987.t2 VDD.t16 pfet_03v3 ad=0.3341p pd=1.805u as=0.5654p ps=3.45u w=1.285u l=0.28u
X8 a_2044_987.t0 CLKN in2.t1 VDD.t5 pfet_03v3 ad=0.5654p pd=3.45u as=0.3341p ps=1.805u w=1.285u l=0.28u
X9 a_2849_203r# out2 VDD.t19 VDD.t18 pfet_03v3 ad=0.3341p pd=1.805u as=0.5654p ps=3.45u w=1.285u l=0.28u
X10 a_913_203r# D.t0 VSS.t13 VSS.t12 nfet_03v3 ad=0.3087p pd=2.01u as=2.81442p ps=15.045u w=1.02u l=0.28u
X11 a_2044_987.t3 out2 VDD.t21 VDD.t20 pfet_03v3 ad=0.3341p pd=1.805u as=0.3341p ps=1.805u w=1.285u l=0.28u
X12 a_828_987.t3 D.t1 VDD.t27 VDD.t26 pfet_03v3 ad=0.3341p pd=1.805u as=0.3341p ps=1.805u w=1.285u l=0.28u
X13 CLKN CLK.t0 VSS.t15 VSS.t14 nfet_03v3 ad=0.3087p pd=2.01u as=2.81442p ps=15.045u w=1.02u l=0.28u
X14 VDD.t13 in2.t7 out2 VDD.t12 pfet_03v3 ad=0.5654p pd=3.45u as=0.3341p ps=1.805u w=1.285u l=0.28u
X15 Q.t2 a_2849_203r# VDD.t9 VDD.t8 pfet_03v3 ad=0.3341p pd=1.805u as=0.3341p ps=1.805u w=1.285u l=0.28u
X16 in2.t3 CLKb.t3 a_2091_203r# VSS.t3 nfet_03v3 ad=0.3087p pd=2.01u as=0.53235p ps=3.25u w=1.02u l=0.28u
X17 VDD.t31 CLK.t1 CLKN VDD.t30 pfet_03v3 ad=0.3341p pd=1.805u as=0.3341p ps=1.805u w=1.285u l=0.28u
X18 in2.t2 CLKN a_913_203r# VSS.t2 nfet_03v3 ad=0.3087p pd=2.01u as=0.52065p ps=3.23u w=1.02u l=0.28u
X19 VDD.t11 a_2849_203r# Q.t0 VDD.t10 pfet_03v3 ad=6.973p pd=42.83u as=0.3341p ps=1.805u w=1.285u l=0.28u
X20 a_2091_203r# out2 VSS.t9 VSS.t8 nfet_03v3 ad=0.3087p pd=2.01u as=2.41237p ps=12.895u w=1.02u l=0.28u
X21 a_2849_203r# out2 VSS.t11 VSS.t10 nfet_03v3 ad=0.3087p pd=2.01u as=2.41237p ps=12.895u w=1.02u l=0.28u
X22 CLKb.t0 CLKN VDD.t1 VDD.t0 pfet_03v3 ad=0.3341p pd=1.805u as=0.3341p ps=1.805u w=1.285u l=0.28u
X23 CLKb.t2 CLKN VSS.t1 VSS.t0 nfet_03v3 ad=0.3087p pd=2.01u as=2.81442p ps=15.045u w=1.02u l=0.28u
X24 in2.t0 CLKN a_2044_987.t1 VDD.t4 pfet_03v3 ad=0.3341p pd=1.805u as=0.3341p ps=1.805u w=1.285u l=0.28u
X25 out2 in2.t6 VSS.t5 VSS.t4 nfet_03v3 ad=0.3087p pd=2.015u as=2.81442p ps=15.045u w=1.02u l=0.28u
X26 in2.t5 CLKb.t5 a_828_987.t1 VDD.t7 pfet_03v3 ad=0.3341p pd=1.805u as=0.3341p ps=1.805u w=1.285u l=0.28u
R0 Q.t1 Q.n1 3.32853
R1 Q Q.n0 2.93192
R2 Q.n0 Q.t2 1.41684
R3 Q.n0 Q.t0 1.41684
R4 Q Q.t1 7.28055
R5 D.n0 D.t1 31.3586
R6 D.n0 D.t2 23.4503
R7 D D.n0 13.907
R8 D D.t0 6.28719
R9 CLK.n0 CLK.t1 40.1505
R10 CLK.n0 CLK.t2 19.2934
R11 CLK CLK.n0 15.7625
R12 CLK CLK.t0 6.59728
R13 VDD.n93 VDD.n92 507.58
R14 VDD.n94 VDD.n26 137.088
R15 VDD.t30 VDD.n54 137.088
R16 VDD.n57 VDD.t30 137.088
R17 VDD.n61 VDD.n51 137.088
R18 VDD.n62 VDD.n61 137.088
R19 VDD.n66 VDD.n47 137.088
R20 VDD.n68 VDD.n44 137.088
R21 VDD.n71 VDD.n44 137.088
R22 VDD.n73 VDD.n41 137.088
R23 VDD.n76 VDD.n41 137.088
R24 VDD.n78 VDD.n40 137.088
R25 VDD.n83 VDD.n82 137.088
R26 VDD.n83 VDD.n36 137.088
R27 VDD.t8 VDD.n87 137.088
R28 VDD.t8 VDD.n33 137.088
R29 VDD.n91 VDD.n29 137.088
R30 VDD.n58 VDD.t2 117.504
R31 VDD.n63 VDD.t26 117.504
R32 VDD.n81 VDD.t4 117.504
R33 VDD.n86 VDD.t18 117.504
R34 VDD.n67 VDD.t7 97.9197
R35 VDD.t6 VDD.n67 97.9197
R36 VDD.n72 VDD.t14 97.9197
R37 VDD.t12 VDD.n72 97.9197
R38 VDD.n77 VDD.t16 97.9197
R39 VDD.t20 VDD.n77 97.9197
R40 VDD.t28 VDD.n26 78.3359
R41 VDD.n58 VDD.t0 78.3359
R42 VDD.n63 VDD.t24 78.3359
R43 VDD.t5 VDD.n81 78.3359
R44 VDD.t22 VDD.n86 78.3359
R45 VDD.t10 VDD.n29 78.3359
R46 VDD.n54 VDD.t28 58.752
R47 VDD.t0 VDD.n57 58.752
R48 VDD.t24 VDD.n62 58.752
R49 VDD.n82 VDD.t5 58.752
R50 VDD.n87 VDD.t22 58.752
R51 VDD.n33 VDD.t10 58.752
R52 VDD.t7 VDD.n66 39.1682
R53 VDD.n68 VDD.t6 39.1682
R54 VDD.t14 VDD.n71 39.1682
R55 VDD.n73 VDD.t12 39.1682
R56 VDD.t16 VDD.n76 39.1682
R57 VDD.n78 VDD.t20 39.1682
R58 VDD.t2 VDD.n51 19.5843
R59 VDD.t26 VDD.n47 19.5843
R60 VDD.n40 VDD.t4 19.5843
R61 VDD.n36 VDD.t18 19.5843
R62 VDD.n96 VDD.n25 9.8005
R63 VDD.n8 VDD.n25 9.8005
R64 VDD.n56 VDD.n8 9.8005
R65 VDD.n19 VDD.n53 2.75725
R66 VDD.n59 VDD.n53 9.8005
R67 VDD.n59 VDD.n52 9.8005
R68 VDD.n23 VDD.n52 2.75725
R69 VDD.n60 VDD.n50 9.8005
R70 VDD.n64 VDD.n50 9.8005
R71 VDD.n64 VDD.n17 2.75725
R72 VDD.n65 VDD.n48 9.8005
R73 VDD.n13 VDD.n46 2.75725
R74 VDD.n69 VDD.n46 9.8005
R75 VDD.n69 VDD.n45 9.8005
R76 VDD.n22 VDD.n45 2.75725
R77 VDD.n70 VDD.n43 9.8005
R78 VDD.n74 VDD.n43 9.8005
R79 VDD.n74 VDD.n21 2.75725
R80 VDD.n75 VDD.n42 9.8005
R81 VDD.n75 VDD.n39 9.8005
R82 VDD.n79 VDD.n14 2.75725
R83 VDD.n79 VDD.n37 9.8005
R84 VDD.n80 VDD.n15 2.75725
R85 VDD.n80 VDD.n35 9.8005
R86 VDD.n84 VDD.n35 9.8005
R87 VDD.n84 VDD.n20 2.75725
R88 VDD.n85 VDD.n34 9.8005
R89 VDD.n85 VDD.n24 9.8005
R90 VDD.n18 VDD.n24 2.75725
R91 VDD.n88 VDD.n12 9.8005
R92 VDD.n89 VDD.n12 9.8005
R93 VDD.n28 VDD.n16 4.8771
R94 VDD.n9 VDD.n27 5.4398
R95 VDD.n6 VDD.n95 4.44191
R96 VDD.n90 VDD.n3 7.02237
R97 VDD.n9 VDD.n7 4.93807
R98 VDD.n10 VDD.n93 6.51963
R99 VDD VDD.n96 6.3005
R100 VDD.n26 VDD.n25 6.3005
R101 VDD VDD.n25 6.3005
R102 VDD.n8 VDD.n54 6.3005
R103 VDD VDD.n8 6.3005
R104 VDD.t30 VDD.n56 6.3005
R105 VDD.n56 VDD.n19 2.75725
R106 VDD.n57 VDD.n53 6.3005
R107 VDD.n19 VDD 1.77287
R108 VDD.n59 VDD.n58 6.3005
R109 VDD VDD.n59 6.3005
R110 VDD.n52 VDD.n51 6.3005
R111 VDD VDD.n23 1.77287
R112 VDD.n61 VDD.n60 6.3005
R113 VDD.n60 VDD.n23 2.75725
R114 VDD.n62 VDD.n50 6.3005
R115 VDD.n50 VDD 6.3005
R116 VDD.n64 VDD.n63 6.3005
R117 VDD VDD.n17 1.77287
R118 VDD.n48 VDD.n47 6.3005
R119 VDD.n17 VDD.n48 2.75725
R120 VDD.n66 VDD.n65 6.3005
R121 VDD.n65 VDD.n13 2.75725
R122 VDD.n67 VDD.n46 6.3005
R123 VDD.n13 VDD.n0 1.77287
R124 VDD.n69 VDD.n68 6.3005
R125 VDD.n0 VDD.n69 6.3005
R126 VDD.n45 VDD.n44 6.3005
R127 VDD.n0 VDD.n22 1.77287
R128 VDD.n71 VDD.n70 6.3005
R129 VDD.n70 VDD.n22 2.75725
R130 VDD.n72 VDD.n43 6.3005
R131 VDD.n43 VDD.n0 6.3005
R132 VDD.n74 VDD.n73 6.3005
R133 VDD.n0 VDD.n21 1.77287
R134 VDD.n42 VDD.n41 6.3005
R135 VDD.n21 VDD.n42 2.75725
R136 VDD.n76 VDD.n75 6.3005
R137 VDD.n75 VDD.n0 6.3005
R138 VDD.n77 VDD.n39 6.3005
R139 VDD.n39 VDD.n14 2.75725
R140 VDD.n79 VDD.n78 6.3005
R141 VDD.n0 VDD.n14 1.77287
R142 VDD.n40 VDD.n37 6.3005
R143 VDD.n15 VDD.n37 2.75725
R144 VDD.n81 VDD.n80 6.3005
R145 VDD.n15 VDD.n0 1.77287
R146 VDD.n82 VDD.n35 6.3005
R147 VDD.n35 VDD.n0 6.3005
R148 VDD.n84 VDD.n83 6.3005
R149 VDD.n0 VDD.n20 1.77287
R150 VDD.n36 VDD.n34 6.3005
R151 VDD.n20 VDD.n34 2.75725
R152 VDD.n86 VDD.n85 6.3005
R153 VDD.n85 VDD.n0 6.3005
R154 VDD.n87 VDD.n24 6.3005
R155 VDD.n0 VDD.n18 1.77287
R156 VDD.n88 VDD.t8 6.3005
R157 VDD.n18 VDD.n88 2.75725
R158 VDD.n33 VDD.n12 6.3005
R159 VDD.n0 VDD.n12 6.3005
R160 VDD.n89 VDD.n29 6.3005
R161 VDD.n89 VDD.n16 2.75725
R162 VDD.n2 VDD.n16 1.77287
R163 VDD.n2 VDD.n90 6.3005
R164 VDD.n91 VDD.n3 6.3005
R165 VDD.n3 VDD.n11 2.32205
R166 VDD.n2 VDD.n11 1.99047
R167 VDD.n92 VDD.n91 6.3005
R168 VDD.n10 VDD.n9 1.80997
R169 VDD.n6 VDD 1.99047
R170 VDD.n7 VDD.n5 2.25551
R171 VDD.n6 VDD.n5 2.32205
R172 VDD.n94 VDD.n7 2.02374
R173 VDD VDD.n49 5.42746
R174 VDD.n0 VDD.n38 5.42746
R175 VDD.n30 VDD.n1 5.4131
R176 VDD.n0 VDD.t13 4.32989
R177 VDD.n0 VDD.t15 4.32989
R178 VDD.n0 VDD.t19 4.32793
R179 VDD VDD.t3 4.32597
R180 VDD.n4 VDD 2.91159
R181 VDD.n0 VDD.n32 2.91159
R182 VDD VDD.n55 2.91159
R183 VDD.n2 VDD.n31 2.90963
R184 VDD.n92 VDD.n1 2.82549
R185 VDD.n93 VDD.n27 2.75725
R186 VDD.n90 VDD.n30 2.68305
R187 VDD.n96 VDD.n95 2.12035
R188 VDD.n11 VDD.n28 4.44191
R189 VDD.n95 VDD.n94 2.09132
R190 VDD.n91 VDD.n28 2.09132
R191 VDD.n2 VDD.n1 2.03587
R192 VDD.n91 VDD.n30 1.80997
R193 VDD.n94 VDD.n27 1.77287
R194 VDD.n0 VDD 1.4285
R195 VDD.n31 VDD.t11 1.41684
R196 VDD.n4 VDD.t29 1.41684
R197 VDD.n32 VDD.t23 1.41684
R198 VDD.n32 VDD.t9 1.41684
R199 VDD.n49 VDD.t25 1.41684
R200 VDD.n49 VDD.t27 1.41684
R201 VDD.n55 VDD.t31 1.41684
R202 VDD.n55 VDD.t1 1.41684
R203 VDD.n38 VDD.t17 1.41684
R204 VDD.n38 VDD.t21 1.41684
R205 VDD.n5 VDD.n4 1.30917
R206 VDD.n31 VDD.n3 1.30917
R207 VDD.n2 VDD.n0 1.2965
R208 VDD.n10 VDD 1.26363
R209 VSS.n102 VSS.n101 576.812
R210 VSS.n105 VSS.n104 513.399
R211 VSS.n59 VSS.n58 513.399
R212 VSS.n60 VSS.n59 513.399
R213 VSS.n64 VSS.n55 513.399
R214 VSS.n65 VSS.n64 513.399
R215 VSS.n66 VSS.n65 513.399
R216 VSS.n70 VSS.n69 513.399
R217 VSS.n71 VSS.n70 513.399
R218 VSS.n74 VSS.n52 513.399
R219 VSS.n75 VSS.n74 513.399
R220 VSS.n76 VSS.n50 513.399
R221 VSS.n79 VSS.n50 513.399
R222 VSS.n80 VSS.n79 513.399
R223 VSS.n81 VSS.n48 513.399
R224 VSS.n84 VSS.n48 513.399
R225 VSS.n85 VSS.n84 513.399
R226 VSS.n86 VSS.n44 513.399
R227 VSS.n89 VSS.n44 513.399
R228 VSS.n91 VSS.n90 513.399
R229 VSS.n91 VSS.n43 513.399
R230 VSS.n95 VSS.n94 513.399
R231 VSS.n96 VSS.n95 513.399
R232 VSS.n96 VSS.n40 513.399
R233 VSS.n86 VSS.t3 495.063
R234 VSS.n69 VSS.t12 490.481
R235 VSS.t4 VSS.n75 421.721
R236 VSS.n60 VSS.t0 380.466
R237 VSS.n90 VSS.t10 343.795
R238 VSS.n43 VSS.t6 325.459
R239 VSS.n58 VSS.t14 288.788
R240 VSS.t8 VSS.n80 288.788
R241 VSS.n71 VSS.t2 265.868
R242 VSS.t2 VSS.n52 247.532
R243 VSS.n105 VSS.t14 224.613
R244 VSS.n81 VSS.t8 224.613
R245 VSS.n94 VSS.t6 187.941
R246 VSS.t10 VSS.n89 169.606
R247 VSS.t0 VSS.n55 132.935
R248 VSS.n76 VSS.t4 91.6789
R249 VSS.n66 VSS.t12 22.9201
R250 VSS.t3 VSS.n85 18.3362
R251 VSS.n97 VSS.n27 2.66071
R252 VSS.n83 VSS.n47 10.8894
R253 VSS.n87 VSS.n26 2.66071
R254 VSS.n87 VSS.n46 10.8894
R255 VSS.n78 VSS.n37 10.8894
R256 VSS.n72 VSS.n53 10.8894
R257 VSS.n24 VSS.n23 2.66071
R258 VSS.n73 VSS.n23 10.8894
R259 VSS.n25 VSS.n35 2.66071
R260 VSS.n106 VSS.n39 10.8894
R261 VSS.n92 VSS.n36 10.8507
R262 VSS.n88 VSS.n28 2.6499
R263 VSS.n29 VSS.n20 2.63743
R264 VSS.n83 VSS.n21 2.61532
R265 VSS.n97 VSS.n38 10.4126
R266 VSS.n67 VSS.n32 10.3869
R267 VSS.n33 VSS.n32 2.58307
R268 VSS.n78 VSS.n34 2.56829
R269 VSS.n77 VSS.n35 10.0648
R270 VSS.n62 VSS.n61 9.94879
R271 VSS.n22 VSS.n53 2.52635
R272 VSS.n93 VSS.n30 2.52293
R273 VSS.n82 VSS.n31 2.50919
R274 VSS.n88 VSS.n3 9.27761
R275 VSS.n0 VSS.n20 8.60291
R276 VSS.n12 VSS.n11 7.42219
R277 VSS.n5 VSS.n39 7.38939
R278 VSS.n98 VSS.n41 7.38939
R279 VSS.n10 VSS.n38 2.32493
R280 VSS.n67 VSS.n17 2.29243
R281 VSS.n63 VSS.n18 5.73544
R282 VSS VSS.n102 5.41963
R283 VSS.n101 VSS.n2 5.41963
R284 VSS.n106 VSS.n105 5.2005
R285 VSS.n1 VSS.n106 3.00607
R286 VSS.n104 VSS.n39 5.2005
R287 VSS.n39 VSS 5.2005
R288 VSS.n59 VSS.n20 5.2005
R289 VSS VSS.n29 1.28278
R290 VSS.n58 VSS.n0 5.2005
R291 VSS.n1 VSS 0.552811
R292 VSS.n61 VSS.n60 5.2005
R293 VSS.n61 VSS.n29 2.63743
R294 VSS.n64 VSS.n63 5.2005
R295 VSS.n63 VSS.n33 2.58307
R296 VSS.n62 VSS.n55 5.2005
R297 VSS.n19 VSS.n62 1.57624
R298 VSS.n65 VSS.n32 5.2005
R299 VSS VSS.n33 1.30997
R300 VSS.n69 VSS.n68 5.2005
R301 VSS.n68 VSS.n22 2.52635
R302 VSS.n67 VSS.n66 5.2005
R303 VSS VSS.n17 1.09824
R304 VSS.n75 VSS.n35 5.2005
R305 VSS VSS.n25 1.27115
R306 VSS.n74 VSS.n73 5.2005
R307 VSS.n73 VSS.n25 2.66071
R308 VSS.n23 VSS.n52 5.2005
R309 VSS VSS.n24 1.27115
R310 VSS.n72 VSS.n71 5.2005
R311 VSS.n24 VSS.n72 2.66071
R312 VSS.n70 VSS.n53 5.2005
R313 VSS.n22 VSS 1.33833
R314 VSS.n13 VSS.n50 5.2005
R315 VSS.n34 VSS.n13 2.56829
R316 VSS.n77 VSS.n76 5.2005
R317 VSS.n77 VSS.n15 1.78773
R318 VSS.n80 VSS.n37 5.2005
R319 VSS.n31 VSS.n37 2.50919
R320 VSS.n79 VSS.n78 5.2005
R321 VSS.n34 VSS 1.31736
R322 VSS.n11 VSS.n48 5.2005
R323 VSS.n21 VSS.n11 2.61532
R324 VSS.n82 VSS.n81 5.2005
R325 VSS.n31 VSS 1.3469
R326 VSS.n46 VSS.n44 5.2005
R327 VSS.n28 VSS.n46 2.6499
R328 VSS.n87 VSS.n86 5.2005
R329 VSS VSS.n26 1.27115
R330 VSS.n85 VSS.n47 5.2005
R331 VSS.n47 VSS.n26 2.66071
R332 VSS.n84 VSS.n83 5.2005
R333 VSS.n21 VSS 1.29384
R334 VSS.n90 VSS.n3 5.2005
R335 VSS.n89 VSS.n88 5.2005
R336 VSS.n28 VSS 1.27655
R337 VSS.n43 VSS.n36 5.2005
R338 VSS.n30 VSS.n36 2.52293
R339 VSS.n92 VSS.n91 5.2005
R340 VSS.n95 VSS.n38 5.2005
R341 VSS VSS.n10 1.08598
R342 VSS.n94 VSS.n93 5.2005
R343 VSS.n30 VSS 1.34003
R344 VSS.n41 VSS.n40 5.2005
R345 VSS.n27 VSS.n41 2.66071
R346 VSS.n97 VSS.n96 5.2005
R347 VSS VSS.n27 1.27115
R348 VSS.n8 VSS.n2 1.27115
R349 VSS.n99 VSS.n8 5.32092
R350 VSS.n98 VSS.n2 5.2005
R351 VSS VSS.n5 5.2005
R352 VSS VSS.n7 1.27115
R353 VSS.n14 VSS.n13 4.9764
R354 VSS.n9 VSS.n42 4.5995
R355 VSS.n3 VSS.n45 4.5995
R356 VSS.n12 VSS.n49 4.5995
R357 VSS.n14 VSS.n51 4.5995
R358 VSS.n16 VSS.n54 4.5995
R359 VSS.n18 VSS.n56 4.5995
R360 VSS.n0 VSS.n57 4.5995
R361 VSS.n14 VSS.n15 1.14829
R362 VSS.n9 VSS.t7 4.4105
R363 VSS.n3 VSS.t11 4.4105
R364 VSS.n12 VSS.t9 4.4105
R365 VSS.n14 VSS.t5 4.4105
R366 VSS.n16 VSS.t13 4.4105
R367 VSS.n18 VSS.t1 4.4105
R368 VSS.n0 VSS.t15 4.4105
R369 VSS VSS.n15 1.33569
R370 VSS.n19 VSS.n18 1.01248
R371 VSS VSS.n19 1.41839
R372 VSS.n17 VSS.n16 1.38908
R373 VSS VSS.n12 3.1505
R374 VSS.n4 VSS.n3 1.21585
R375 VSS.n10 VSS.n9 1.40876
R376 VSS.n68 VSS.n16 3.05697
R377 VSS.n93 VSS.n9 2.8883
R378 VSS.n102 VSS.n6 2.66071
R379 VSS.n101 VSS.n100 2.66071
R380 VSS.n103 VSS.n5 2.66071
R381 VSS.n103 VSS.n7 5.32092
R382 VSS.n7 VSS.n6 5.32092
R383 VSS.n99 VSS.n98 2.66071
R384 VSS.n100 VSS.n8 5.32092
R385 VSS.n92 VSS.n4 3.00215
R386 VSS.n12 VSS.n82 2.2136
R387 VSS.n1 VSS.n0 1.92998
R388 VSS VSS.n4 1.39921
R389 VSS.n100 VSS.n40 1.27115
R390 VSS.n99 VSS.n40 1.27115
R391 VSS.n104 VSS.n103 1.27115
R392 VSS.n104 VSS.n6 1.27115
R393 VSS.n2 VSS 1.02426
R394 a_2044_987.n1 a_2044_987.t2 4.91293
R395 a_2044_987.t0 a_2044_987.n1 4.89923
R396 a_2044_987.n1 a_2044_987.n0 2.6005
R397 a_2044_987.n0 a_2044_987.t1 1.41684
R398 a_2044_987.n0 a_2044_987.t3 1.41684
R399 a_828_987.n1 a_828_987.t2 4.91293
R400 a_828_987.t0 a_828_987.n1 4.89923
R401 a_828_987.n1 a_828_987.n0 2.6005
R402 a_828_987.n0 a_828_987.t1 1.41684
R403 a_828_987.n0 a_828_987.t3 1.41684
R404 in2.n3 in2.t7 40.1505
R405 in2.n5 in2.n3 28.0278
R406 in2.n3 in2.t8 19.2934
R407 in2.n0 in2.n1 10.5571
R408 in2.n7 in2.n5 8.08665
R409 in2.n7 in2.t2 6.98303
R410 in2 in2.n0 5.4467
R411 in2.n5 in2.n4 5.2005
R412 in2.n8 in2.t6 7.31032
R413 in2.n1 in2.t0 1.41684
R414 in2.n1 in2.t1 1.41684
R415 in2.n4 in2.t5 1.41684
R416 in2.n4 in2.t4 1.41684
R417 in2.t2 in2.n6 0.956717
R418 in2.n8 in2.n7 0.842256
R419 in2 in2.n8 0.840308
R420 in2.t3 in2.n0 11.647
R421 in2.n2 in2.t3 3.14486
R422 CLKb.n0 CLKb.t4 40.1505
R423 CLKb.n0 CLKb.t5 19.2934
R424 CLKb.n1 CLKb.n0 11.1192
R425 CLKb.n1 CLKb.t3 13.8385
R426 CLKb CLKb.n3 5.20282
R427 CLKb.t2 CLKb.n4 3.32853
R428 CLKb.n3 CLKb.n2 3.02537
R429 CLKb.n2 CLKb.t0 1.41684
R430 CLKb.n2 CLKb.t1 1.41684
R431 CLKb CLKb.t2 12.0115
R432 CLKb.n3 CLKb.n1 1.2213
C0 VDD Q 0.53846f
C1 VDD CLK 0.58708f
C2 CLKb out2 0.55873f
C3 CLKb VDD 0.88467f
C4 a_2849_203r# Q 0.46235f
C5 CLKN D 0.56888f
C6 in2 D 0.10566f
C7 CLKb D 0.44498f
C8 CLKN in2 0.75776f
C9 out2 a_2091_203r# 0.39622f
C10 CLKN CLK 0.48557f
C11 D a_913_203r# 0.13857f
C12 out2 VDD 1.23165f
C13 CLKb CLKN 1.51495f
C14 CLKb in2 1.02589f
C15 in2 a_913_203r# 0.1082f
C16 out2 a_2849_203r# 0.56903f
C17 VDD a_2849_203r# 0.79864f
C18 D VDD 0.3308f
C19 CLKN out2 0.7722f
C20 in2 out2 1.31587f
C21 CLKN VDD 1.29288f
C22 in2 VDD 0.53702f
C23 Q VSS 0.86015f
C24 D VSS 1.07991f
C25 CLK VSS 1.05078f
C26 VDD VSS 10.21504f
C27 a_2091_203r# VSS 0.10841f
C28 a_913_203r# VSS 0.11335f
C29 a_2849_203r# VSS 0.57848f
C30 out2 VSS 1.06609f
C31 in2 VSS 1.05614f
C32 CLKb VSS 1.16999f
C33 CLKN VSS 1.09459f
C34 CLKb.t2 VSS 0.29903f
C35 CLKb.t5 VSS 0.10042f
C36 CLKb.t4 VSS 0.16013f
C37 CLKb.n0 VSS 0.1727f
C38 CLKb.t3 VSS 0.9463f
C39 CLKb.n1 VSS 1.41454f
C40 CLKb.n2 VSS 0.16771f
C41 CLKb.n3 VSS 0.40374f
C42 CLKb.n4 VSS 0.2803f
C43 in2.n0 VSS 0.60568f
C44 in2.t3 VSS 0.20066f
C45 in2.n1 VSS 0.18106f
C46 in2.n2 VSS 0.11298f
C47 in2.t7 VSS 0.12961f
C48 in2.n3 VSS 0.18577f
C49 in2.n4 VSS 0.12199f
C50 in2.n5 VSS 0.43231f
C51 in2.n6 VSS 0.29777f
C52 in2.n7 VSS 0.39333f
C53 in2.t6 VSS 0.60702f
C54 in2.n8 VSS 0.4497f
C55 a_828_987.t2 VSS 0.26933f
C56 a_828_987.n0 VSS 0.17069f
C57 a_828_987.n1 VSS 0.76106f
C58 a_828_987.t0 VSS 0.26826f
C59 a_2044_987.t2 VSS 0.25502f
C60 a_2044_987.n0 VSS 0.16162f
C61 a_2044_987.n1 VSS 0.72062f
C62 a_2044_987.t0 VSS 0.254f
C63 VDD.n0 VSS 0.62707f
C64 VDD.n2 VSS 0.10682f
C65 VDD.n26 VSS 0.13268f
C66 VDD.n29 VSS 0.13268f
C67 VDD.n33 VSS 0.12061f
C68 VDD.n41 VSS 0.16886f
C69 VDD.n44 VSS 0.16886f
C70 VDD.n54 VSS 0.12061f
C71 VDD.t30 VSS 0.16886f
C72 VDD.n57 VSS 0.12061f
C73 VDD.n58 VSS 0.12061f
C74 VDD.n61 VSS 0.16886f
C75 VDD.n62 VSS 0.12061f
C76 VDD.n63 VSS 0.12061f
C77 VDD.n66 VSS 0.10855f
C78 VDD.n67 VSS 0.12061f
C79 VDD.n68 VSS 0.10855f
C80 VDD.n71 VSS 0.10855f
C81 VDD.n72 VSS 0.12061f
C82 VDD.n73 VSS 0.10855f
C83 VDD.n76 VSS 0.10855f
C84 VDD.n77 VSS 0.12061f
C85 VDD.n78 VSS 0.10855f
C86 VDD.n81 VSS 0.12061f
C87 VDD.n82 VSS 0.12061f
C88 VDD.n83 VSS 0.16886f
C89 VDD.n86 VSS 0.12061f
C90 VDD.n87 VSS 0.12061f
C91 VDD.t8 VSS 0.16886f
C92 VDD.n91 VSS 0.26837f
C93 VDD.n92 VSS 0.15679f
C94 VDD.n93 VSS 0.15679f
C95 VDD.n94 VSS 0.22012f
C96 CLK.t0 VSS 0.41524f
C97 CLK.n0 VSS 0.10478f
C98 D.t1 VSS 0.12541f
C99 D.t2 VSS 0.10488f
C100 D.n0 VSS 0.29294f
C101 D.t0 VSS 0.66064f
C102 Q.t1 VSS 0.16313f
C103 Q.n0 VSS 0.10055f
C104 Q.n1 VSS 0.17304f
.ends
