* NGSPICE file created from gf180mcu_ocd_sc_rt12t3v3__dlatn_1.ext - technology: gf180mcuD

.subckt gf180mcu_ocd_sc_rt12t3v3__dlatn_1 D CLK Q VDD VSS
X0 a_828_987.t0 CLKb.t4 in2.t3 VDD.t6 pfet_03v3 ad=0.5654p pd=3.45u as=0.3341p ps=1.805u w=1.285u l=0.28u
X1 out2 in2.t8 VDD.t26 VDD.t25 pfet_03v3 ad=0.3341p pd=1.805u as=0.5654p ps=3.45u w=1.285u l=0.28u
X2 Q.t1 a_2849_203r# VSS.t6 VSS.t5 nfet_03v3 ad=0.3087p pd=2.01u as=2.81442p ps=15.045u w=1.02u l=0.28u
X3 VDD.t18 out2 a_2849_203r# VDD.t17 pfet_03v3 ad=0.3341p pd=1.805u as=0.3341p ps=1.805u w=1.285u l=0.28u
X4 CLKN CLK.t2 VDD.t20 VDD.t19 pfet_03v3 ad=0.3341p pd=1.805u as=6.973p ps=42.83u w=1.285u l=0.28u
X5 VDD.t3 CLKN CLKb.t1 VDD.t2 pfet_03v3 ad=0.5654p pd=3.45u as=0.3341p ps=1.805u w=1.285u l=0.28u
X6 VDD.t28 D.t2 a_828_987.t1 VDD.t27 pfet_03v3 ad=0.3341p pd=1.805u as=0.5654p ps=3.45u w=1.285u l=0.28u
X7 VDD.t14 out2 a_2044_987.t2 VDD.t13 pfet_03v3 ad=0.3341p pd=1.805u as=0.5654p ps=3.45u w=1.285u l=0.28u
X8 a_2044_987.t0 CLKN in2.t2 VDD.t5 pfet_03v3 ad=0.5654p pd=3.45u as=0.3341p ps=1.805u w=1.285u l=0.28u
X9 a_2849_203r# out2 VDD.t12 VDD.t11 pfet_03v3 ad=0.3341p pd=1.805u as=0.5654p ps=3.45u w=1.285u l=0.28u
X10 a_913_203r# D.t0 VSS.t15 VSS.t14 nfet_03v3 ad=0.3087p pd=2.01u as=2.81442p ps=15.045u w=1.02u l=0.28u
X11 a_2044_987.t3 out2 VDD.t16 VDD.t15 pfet_03v3 ad=0.3341p pd=1.805u as=0.3341p ps=1.805u w=1.285u l=0.28u
X12 a_828_987.t2 D.t1 VDD.t30 VDD.t29 pfet_03v3 ad=0.3341p pd=1.805u as=0.3341p ps=1.805u w=1.285u l=0.28u
X13 CLKN CLK.t0 VSS.t12 VSS.t11 nfet_03v3 ad=0.3087p pd=2.01u as=2.81442p ps=15.045u w=1.02u l=0.28u
X14 VDD.t24 in2.t7 out2 VDD.t23 pfet_03v3 ad=0.5654p pd=3.45u as=0.3341p ps=1.805u w=1.285u l=0.28u
X15 Q.t0 a_2849_203r# VDD.t8 VDD.t7 pfet_03v3 ad=0.3341p pd=1.805u as=0.3341p ps=1.805u w=1.285u l=0.28u
X16 in2.t4 CLKb.t3 a_2091_203r# VSS.t13 nfet_03v3 ad=0.3087p pd=2.01u as=0.53235p ps=3.25u w=1.02u l=0.28u
X17 VDD.t22 CLK.t1 CLKN VDD.t21 pfet_03v3 ad=0.3341p pd=1.805u as=0.3341p ps=1.805u w=1.285u l=0.28u
X18 in2.t0 CLKN a_913_203r# VSS.t2 nfet_03v3 ad=0.3087p pd=2.01u as=0.52065p ps=3.23u w=1.02u l=0.28u
X19 VDD.t10 a_2849_203r# Q.t2 VDD.t9 pfet_03v3 ad=6.973p pd=42.83u as=0.3341p ps=1.805u w=1.285u l=0.28u
X20 a_2091_203r# out2 VSS.t8 VSS.t7 nfet_03v3 ad=0.3087p pd=2.01u as=2.41237p ps=12.895u w=1.02u l=0.28u
X21 a_2849_203r# out2 VSS.t10 VSS.t9 nfet_03v3 ad=0.3087p pd=2.01u as=2.41237p ps=12.895u w=1.02u l=0.28u
X22 CLKb.t0 CLKN VDD.t1 VDD.t0 pfet_03v3 ad=0.3341p pd=1.805u as=0.3341p ps=1.805u w=1.285u l=0.28u
X23 CLKb.t2 CLKN VSS.t1 VSS.t0 nfet_03v3 ad=0.3087p pd=2.01u as=2.81442p ps=15.045u w=1.02u l=0.28u
X24 in2.t1 CLKN a_2044_987.t1 VDD.t4 pfet_03v3 ad=0.3341p pd=1.805u as=0.3341p ps=1.805u w=1.285u l=0.28u
X25 out2 in2.t6 VSS.t4 VSS.t3 nfet_03v3 ad=0.3087p pd=2.015u as=2.81442p ps=15.045u w=1.02u l=0.28u
X26 in2.t5 CLKb.t5 a_828_987.t3 VDD.t31 pfet_03v3 ad=0.3341p pd=1.805u as=0.3341p ps=1.805u w=1.285u l=0.28u
R0 Q.n6 Q.t1 50.9005
R1 Q.n2 Q.n7 32.5888
R2 Q.n7 Q.n6 16.9387
R3 Q.n6 Q.n0 11.9058
R4 Q Q.n3 6.5781
R5 Q.n3 Q.n0 3.31861
R6 Q.n7 Q.n4 3.6505
R7 Q Q.n5 2.93192
R8 Q.n2 Q.n0 0.0474974
R9 Q.n1 Q.t1 0.459182
R10 Q.n1 Q.n4 0.825727
R11 Q.n5 Q.t0 1.41684
R12 Q.n5 Q.t2 1.41684
R13 Q.n3 Q.t1 5.88322
R14 Q.n3 Q.n4 1.7588
R15 Q.n2 Q.n1 1.57306
R16 D.n0 D.t1 31.3586
R17 D.n0 D.t2 23.4503
R18 D D.n0 13.907
R19 D D.t0 6.75352
R20 CLK.n0 CLK.t1 40.1505
R21 CLK.n0 CLK.t2 19.2934
R22 CLK CLK.n0 15.7625
R23 CLK CLK.t0 7.00022
R24 VDD.n93 VDD.n92 507.58
R25 VDD.n94 VDD.n26 137.088
R26 VDD.t21 VDD.n54 137.088
R27 VDD.n57 VDD.t21 137.088
R28 VDD.n61 VDD.n51 137.088
R29 VDD.n62 VDD.n61 137.088
R30 VDD.n66 VDD.n47 137.088
R31 VDD.n68 VDD.n44 137.088
R32 VDD.n71 VDD.n44 137.088
R33 VDD.n73 VDD.n41 137.088
R34 VDD.n76 VDD.n41 137.088
R35 VDD.n78 VDD.n40 137.088
R36 VDD.n83 VDD.n82 137.088
R37 VDD.n83 VDD.n36 137.088
R38 VDD.t7 VDD.n87 137.088
R39 VDD.t7 VDD.n33 137.088
R40 VDD.n91 VDD.n29 137.088
R41 VDD.n58 VDD.t2 117.504
R42 VDD.n63 VDD.t29 117.504
R43 VDD.n81 VDD.t4 117.504
R44 VDD.n86 VDD.t11 117.504
R45 VDD.n67 VDD.t31 97.9197
R46 VDD.t6 VDD.n67 97.9197
R47 VDD.n72 VDD.t25 97.9197
R48 VDD.t23 VDD.n72 97.9197
R49 VDD.n77 VDD.t13 97.9197
R50 VDD.t15 VDD.n77 97.9197
R51 VDD.t19 VDD.n26 78.3359
R52 VDD.n58 VDD.t0 78.3359
R53 VDD.n63 VDD.t27 78.3359
R54 VDD.t5 VDD.n81 78.3359
R55 VDD.t17 VDD.n86 78.3359
R56 VDD.t9 VDD.n29 78.3359
R57 VDD.n54 VDD.t19 58.752
R58 VDD.t0 VDD.n57 58.752
R59 VDD.t27 VDD.n62 58.752
R60 VDD.n82 VDD.t5 58.752
R61 VDD.n87 VDD.t17 58.752
R62 VDD.n33 VDD.t9 58.752
R63 VDD.t31 VDD.n66 39.1682
R64 VDD.n68 VDD.t6 39.1682
R65 VDD.t25 VDD.n71 39.1682
R66 VDD.n73 VDD.t23 39.1682
R67 VDD.t13 VDD.n76 39.1682
R68 VDD.n78 VDD.t15 39.1682
R69 VDD.t2 VDD.n51 19.5843
R70 VDD.t29 VDD.n47 19.5843
R71 VDD.n40 VDD.t4 19.5843
R72 VDD.n36 VDD.t11 19.5843
R73 VDD.n96 VDD.n25 9.8005
R74 VDD.n8 VDD.n25 9.8005
R75 VDD.n56 VDD.n8 9.8005
R76 VDD.n19 VDD.n53 2.75725
R77 VDD.n59 VDD.n53 9.8005
R78 VDD.n59 VDD.n52 9.8005
R79 VDD.n23 VDD.n52 2.75725
R80 VDD.n60 VDD.n50 9.8005
R81 VDD.n64 VDD.n50 9.8005
R82 VDD.n64 VDD.n17 2.75725
R83 VDD.n65 VDD.n48 9.8005
R84 VDD.n13 VDD.n46 2.75725
R85 VDD.n69 VDD.n46 9.8005
R86 VDD.n69 VDD.n45 9.8005
R87 VDD.n22 VDD.n45 2.75725
R88 VDD.n70 VDD.n43 9.8005
R89 VDD.n74 VDD.n43 9.8005
R90 VDD.n74 VDD.n21 2.75725
R91 VDD.n75 VDD.n42 9.8005
R92 VDD.n75 VDD.n39 9.8005
R93 VDD.n79 VDD.n14 2.75725
R94 VDD.n79 VDD.n37 9.8005
R95 VDD.n80 VDD.n15 2.75725
R96 VDD.n80 VDD.n35 9.8005
R97 VDD.n84 VDD.n35 9.8005
R98 VDD.n84 VDD.n20 2.75725
R99 VDD.n85 VDD.n34 9.8005
R100 VDD.n85 VDD.n24 9.8005
R101 VDD.n18 VDD.n24 2.75725
R102 VDD.n88 VDD.n12 9.8005
R103 VDD.n89 VDD.n12 9.8005
R104 VDD.n28 VDD.n16 4.8771
R105 VDD.n9 VDD.n27 5.4398
R106 VDD.n6 VDD.n95 4.44191
R107 VDD.n90 VDD.n3 7.02237
R108 VDD.n9 VDD.n7 4.93807
R109 VDD.n10 VDD.n93 6.51963
R110 VDD VDD.n96 6.3005
R111 VDD.n26 VDD.n25 6.3005
R112 VDD VDD.n25 6.3005
R113 VDD.n8 VDD.n54 6.3005
R114 VDD VDD.n8 6.3005
R115 VDD.t21 VDD.n56 6.3005
R116 VDD.n56 VDD.n19 2.75725
R117 VDD.n57 VDD.n53 6.3005
R118 VDD.n19 VDD 1.77287
R119 VDD.n59 VDD.n58 6.3005
R120 VDD VDD.n59 6.3005
R121 VDD.n52 VDD.n51 6.3005
R122 VDD VDD.n23 1.77287
R123 VDD.n61 VDD.n60 6.3005
R124 VDD.n60 VDD.n23 2.75725
R125 VDD.n62 VDD.n50 6.3005
R126 VDD.n50 VDD 6.3005
R127 VDD.n64 VDD.n63 6.3005
R128 VDD VDD.n17 1.77287
R129 VDD.n48 VDD.n47 6.3005
R130 VDD.n17 VDD.n48 2.75725
R131 VDD.n66 VDD.n65 6.3005
R132 VDD.n65 VDD.n13 2.75725
R133 VDD.n67 VDD.n46 6.3005
R134 VDD.n13 VDD.n0 1.77287
R135 VDD.n69 VDD.n68 6.3005
R136 VDD.n0 VDD.n69 6.3005
R137 VDD.n45 VDD.n44 6.3005
R138 VDD.n0 VDD.n22 1.77287
R139 VDD.n71 VDD.n70 6.3005
R140 VDD.n70 VDD.n22 2.75725
R141 VDD.n72 VDD.n43 6.3005
R142 VDD.n43 VDD.n0 6.3005
R143 VDD.n74 VDD.n73 6.3005
R144 VDD.n0 VDD.n21 1.77287
R145 VDD.n42 VDD.n41 6.3005
R146 VDD.n21 VDD.n42 2.75725
R147 VDD.n76 VDD.n75 6.3005
R148 VDD.n75 VDD.n0 6.3005
R149 VDD.n77 VDD.n39 6.3005
R150 VDD.n39 VDD.n14 2.75725
R151 VDD.n79 VDD.n78 6.3005
R152 VDD.n0 VDD.n14 1.77287
R153 VDD.n40 VDD.n37 6.3005
R154 VDD.n15 VDD.n37 2.75725
R155 VDD.n81 VDD.n80 6.3005
R156 VDD.n15 VDD.n0 1.77287
R157 VDD.n82 VDD.n35 6.3005
R158 VDD.n35 VDD.n0 6.3005
R159 VDD.n84 VDD.n83 6.3005
R160 VDD.n0 VDD.n20 1.77287
R161 VDD.n36 VDD.n34 6.3005
R162 VDD.n20 VDD.n34 2.75725
R163 VDD.n86 VDD.n85 6.3005
R164 VDD.n85 VDD.n0 6.3005
R165 VDD.n87 VDD.n24 6.3005
R166 VDD.n0 VDD.n18 1.77287
R167 VDD.n88 VDD.t7 6.3005
R168 VDD.n18 VDD.n88 2.75725
R169 VDD.n33 VDD.n12 6.3005
R170 VDD.n0 VDD.n12 6.3005
R171 VDD.n89 VDD.n29 6.3005
R172 VDD.n89 VDD.n16 2.75725
R173 VDD.n2 VDD.n16 1.77287
R174 VDD.n2 VDD.n90 6.3005
R175 VDD.n91 VDD.n3 6.3005
R176 VDD.n3 VDD.n11 2.32205
R177 VDD.n2 VDD.n11 1.99047
R178 VDD.n92 VDD.n91 6.3005
R179 VDD.n10 VDD.n9 1.80997
R180 VDD.n6 VDD 1.99047
R181 VDD.n7 VDD.n5 2.25551
R182 VDD.n6 VDD.n5 2.32205
R183 VDD.n94 VDD.n7 2.02374
R184 VDD VDD.n49 5.42746
R185 VDD.n0 VDD.n38 5.42746
R186 VDD.n30 VDD.n1 5.4131
R187 VDD.n0 VDD.t24 4.32989
R188 VDD.n0 VDD.t26 4.32989
R189 VDD.n0 VDD.t12 4.32793
R190 VDD VDD.t3 4.32597
R191 VDD.n4 VDD 2.91159
R192 VDD.n0 VDD.n32 2.91159
R193 VDD VDD.n55 2.91159
R194 VDD.n2 VDD.n31 2.90963
R195 VDD.n92 VDD.n1 2.82549
R196 VDD.n93 VDD.n27 2.75725
R197 VDD.n90 VDD.n30 2.68305
R198 VDD.n96 VDD.n95 2.12035
R199 VDD.n11 VDD.n28 4.44191
R200 VDD.n95 VDD.n94 2.09132
R201 VDD.n91 VDD.n28 2.09132
R202 VDD.n2 VDD.n1 2.03587
R203 VDD.n91 VDD.n30 1.80997
R204 VDD.n94 VDD.n27 1.77287
R205 VDD.n0 VDD 1.4285
R206 VDD.n31 VDD.t10 1.41684
R207 VDD.n4 VDD.t20 1.41684
R208 VDD.n32 VDD.t18 1.41684
R209 VDD.n32 VDD.t8 1.41684
R210 VDD.n49 VDD.t28 1.41684
R211 VDD.n49 VDD.t30 1.41684
R212 VDD.n55 VDD.t22 1.41684
R213 VDD.n55 VDD.t1 1.41684
R214 VDD.n38 VDD.t14 1.41684
R215 VDD.n38 VDD.t16 1.41684
R216 VDD.n5 VDD.n4 1.30917
R217 VDD.n31 VDD.n3 1.30917
R218 VDD.n2 VDD.n0 1.2965
R219 VDD.n10 VDD 1.26363
R220 VSS.n102 VSS.n101 576.812
R221 VSS.n105 VSS.n104 513.399
R222 VSS.n59 VSS.n58 513.399
R223 VSS.n60 VSS.n59 513.399
R224 VSS.n64 VSS.n55 513.399
R225 VSS.n65 VSS.n64 513.399
R226 VSS.n66 VSS.n65 513.399
R227 VSS.n70 VSS.n69 513.399
R228 VSS.n71 VSS.n70 513.399
R229 VSS.n74 VSS.n52 513.399
R230 VSS.n75 VSS.n74 513.399
R231 VSS.n76 VSS.n50 513.399
R232 VSS.n79 VSS.n50 513.399
R233 VSS.n80 VSS.n79 513.399
R234 VSS.n81 VSS.n48 513.399
R235 VSS.n84 VSS.n48 513.399
R236 VSS.n85 VSS.n84 513.399
R237 VSS.n86 VSS.n44 513.399
R238 VSS.n89 VSS.n44 513.399
R239 VSS.n91 VSS.n90 513.399
R240 VSS.n91 VSS.n43 513.399
R241 VSS.n95 VSS.n94 513.399
R242 VSS.n96 VSS.n95 513.399
R243 VSS.n96 VSS.n40 513.399
R244 VSS.n86 VSS.t13 495.063
R245 VSS.n69 VSS.t14 490.481
R246 VSS.t3 VSS.n75 421.721
R247 VSS.n60 VSS.t0 380.466
R248 VSS.n90 VSS.t9 343.795
R249 VSS.n43 VSS.t5 325.459
R250 VSS.n58 VSS.t11 288.788
R251 VSS.t7 VSS.n80 288.788
R252 VSS.n71 VSS.t2 265.868
R253 VSS.t2 VSS.n52 247.532
R254 VSS.n105 VSS.t11 224.613
R255 VSS.n81 VSS.t7 224.613
R256 VSS.n94 VSS.t5 187.941
R257 VSS.t9 VSS.n89 169.606
R258 VSS.t0 VSS.n55 132.935
R259 VSS.n76 VSS.t3 91.6789
R260 VSS.n66 VSS.t14 22.9201
R261 VSS.t13 VSS.n85 18.3362
R262 VSS.n97 VSS.n27 2.66071
R263 VSS.n83 VSS.n47 10.8894
R264 VSS.n87 VSS.n26 2.66071
R265 VSS.n87 VSS.n46 10.8894
R266 VSS.n78 VSS.n37 10.8894
R267 VSS.n72 VSS.n53 10.8894
R268 VSS.n24 VSS.n23 2.66071
R269 VSS.n73 VSS.n23 10.8894
R270 VSS.n25 VSS.n35 2.66071
R271 VSS.n106 VSS.n39 10.8894
R272 VSS.n92 VSS.n36 10.8507
R273 VSS.n88 VSS.n28 2.6499
R274 VSS.n29 VSS.n20 2.63743
R275 VSS.n83 VSS.n21 2.61532
R276 VSS.n97 VSS.n38 10.4126
R277 VSS.n67 VSS.n32 10.3869
R278 VSS.n33 VSS.n32 2.58307
R279 VSS.n78 VSS.n34 2.56829
R280 VSS.n77 VSS.n35 10.0648
R281 VSS.n62 VSS.n61 9.94879
R282 VSS.n22 VSS.n53 2.52635
R283 VSS.n93 VSS.n30 2.52293
R284 VSS.n82 VSS.n31 2.50919
R285 VSS.n88 VSS.n3 9.27761
R286 VSS.n0 VSS.n20 8.60291
R287 VSS.n12 VSS.n11 7.42219
R288 VSS.n5 VSS.n39 7.38939
R289 VSS.n98 VSS.n41 7.38939
R290 VSS.n10 VSS.n38 2.32493
R291 VSS.n67 VSS.n17 2.29243
R292 VSS.n63 VSS.n18 5.73544
R293 VSS VSS.n102 5.41963
R294 VSS.n101 VSS.n2 5.41963
R295 VSS.n106 VSS.n105 5.2005
R296 VSS.n1 VSS.n106 3.00607
R297 VSS.n104 VSS.n39 5.2005
R298 VSS.n39 VSS 5.2005
R299 VSS.n59 VSS.n20 5.2005
R300 VSS VSS.n29 1.28278
R301 VSS.n58 VSS.n0 5.2005
R302 VSS.n1 VSS 0.552811
R303 VSS.n61 VSS.n60 5.2005
R304 VSS.n61 VSS.n29 2.63743
R305 VSS.n64 VSS.n63 5.2005
R306 VSS.n63 VSS.n33 2.58307
R307 VSS.n62 VSS.n55 5.2005
R308 VSS VSS.n19 1.35911
R309 VSS.n65 VSS.n32 5.2005
R310 VSS VSS.n33 1.30997
R311 VSS.n69 VSS.n68 5.2005
R312 VSS.n68 VSS.n22 2.52635
R313 VSS.n67 VSS.n66 5.2005
R314 VSS VSS.n17 1.09824
R315 VSS.n75 VSS.n35 5.2005
R316 VSS VSS.n25 1.27115
R317 VSS.n74 VSS.n73 5.2005
R318 VSS.n73 VSS.n25 2.66071
R319 VSS.n23 VSS.n52 5.2005
R320 VSS VSS.n24 1.27115
R321 VSS.n72 VSS.n71 5.2005
R322 VSS.n24 VSS.n72 2.66071
R323 VSS.n70 VSS.n53 5.2005
R324 VSS.n22 VSS 1.33833
R325 VSS.n13 VSS.n50 5.2005
R326 VSS.n34 VSS.n13 2.56829
R327 VSS.n77 VSS.n76 5.2005
R328 VSS.n15 VSS 1.2787
R329 VSS.n80 VSS.n37 5.2005
R330 VSS.n31 VSS.n37 2.50919
R331 VSS.n79 VSS.n78 5.2005
R332 VSS.n34 VSS 1.31736
R333 VSS.n11 VSS.n48 5.2005
R334 VSS.n21 VSS.n11 2.61532
R335 VSS.n82 VSS.n81 5.2005
R336 VSS.n31 VSS 1.3469
R337 VSS.n46 VSS.n44 5.2005
R338 VSS.n28 VSS.n46 2.6499
R339 VSS.n87 VSS.n86 5.2005
R340 VSS VSS.n26 1.27115
R341 VSS.n85 VSS.n47 5.2005
R342 VSS.n47 VSS.n26 2.66071
R343 VSS.n84 VSS.n83 5.2005
R344 VSS.n21 VSS 1.29384
R345 VSS.n90 VSS.n3 5.2005
R346 VSS.n89 VSS.n88 5.2005
R347 VSS.n28 VSS 1.27655
R348 VSS.n43 VSS.n36 5.2005
R349 VSS.n30 VSS.n36 2.52293
R350 VSS.n92 VSS.n91 5.2005
R351 VSS.n95 VSS.n38 5.2005
R352 VSS VSS.n10 1.08598
R353 VSS.n94 VSS.n93 5.2005
R354 VSS.n30 VSS 1.34003
R355 VSS.n41 VSS.n40 5.2005
R356 VSS.n27 VSS.n41 2.66071
R357 VSS.n97 VSS.n96 5.2005
R358 VSS VSS.n27 1.27115
R359 VSS.n8 VSS.n2 1.27115
R360 VSS.n99 VSS.n8 5.32092
R361 VSS.n98 VSS.n2 5.2005
R362 VSS VSS.n5 5.2005
R363 VSS VSS.n7 1.27115
R364 VSS.n14 VSS.n13 4.9764
R365 VSS.n15 VSS.n77 1.81407
R366 VSS.n9 VSS.t6 4.4105
R367 VSS.n3 VSS.t10 4.4105
R368 VSS.n12 VSS.t8 4.4105
R369 VSS.n14 VSS.t4 4.4105
R370 VSS.n16 VSS.t15 4.4105
R371 VSS.n18 VSS.t1 4.4105
R372 VSS.n0 VSS.t12 4.4105
R373 VSS.n62 VSS.n19 1.60092
R374 VSS.n19 VSS.n18 0.970182
R375 VSS.n17 VSS.n16 1.38908
R376 VSS.n15 VSS.n14 1.0993
R377 VSS VSS.n12 3.1505
R378 VSS.n4 VSS.n3 1.21585
R379 VSS.n10 VSS.n9 1.40876
R380 VSS.n18 VSS.n56 2.9615
R381 VSS.n16 VSS.n54 2.9615
R382 VSS.n14 VSS.n51 2.9615
R383 VSS.n93 VSS.n9 2.8883
R384 VSS.n68 VSS.n16 2.86797
R385 VSS.n9 VSS.n42 2.7725
R386 VSS.n3 VSS.n45 2.7725
R387 VSS.n12 VSS.n49 2.7725
R388 VSS.n0 VSS.n57 2.7725
R389 VSS.n102 VSS.n6 2.66071
R390 VSS.n101 VSS.n100 2.66071
R391 VSS.n103 VSS.n5 2.66071
R392 VSS.n103 VSS.n7 5.32092
R393 VSS.n7 VSS.n6 5.32092
R394 VSS.n99 VSS.n98 2.66071
R395 VSS.n100 VSS.n8 5.32092
R396 VSS.n92 VSS.n4 3.00215
R397 VSS.n12 VSS.n82 2.2136
R398 VSS.n1 VSS.n0 1.92998
R399 VSS VSS.n4 1.39921
R400 VSS.n100 VSS.n40 1.27115
R401 VSS.n99 VSS.n40 1.27115
R402 VSS.n104 VSS.n103 1.27115
R403 VSS.n104 VSS.n6 1.27115
R404 VSS.n2 VSS 1.02426
R405 a_2044_987.t2 a_2044_987.n1 4.91293
R406 a_2044_987.n1 a_2044_987.t0 4.89923
R407 a_2044_987.n1 a_2044_987.n0 2.6005
R408 a_2044_987.n0 a_2044_987.t1 1.41684
R409 a_2044_987.n0 a_2044_987.t3 1.41684
R410 a_828_987.n0 a_828_987.t1 4.91293
R411 a_828_987.n0 a_828_987.t0 4.89923
R412 a_828_987.n1 a_828_987.n0 2.6005
R413 a_828_987.n1 a_828_987.t3 1.41684
R414 a_828_987.t2 a_828_987.n1 1.41684
R415 in2.t0 in2.n26 111.456
R416 in2.n15 in2.n9 88.7005
R417 in2.n28 in2.n27 88.7005
R418 in2.n11 in2.n1 85.0505
R419 in2.t0 in2.n6 1.69161
R420 in2.n17 in2.n1 47.4817
R421 in2.n9 in2.n1 47.2505
R422 in2.n12 in2.n11 47.2505
R423 in2.n27 in2.n24 47.2505
R424 in2.n21 in2.t7 40.1505
R425 in2.n23 in2.n21 28.0278
R426 in2.n21 in2.t8 19.2934
R427 in2.n5 in2.n30 5.12143
R428 in2.n16 in2.n4 16.6848
R429 in2.n30 in2.n28 15.5491
R430 in2.n8 in2.n15 14.1318
R431 in2.n18 in2.t4 13.6505
R432 in2.n20 in2.n19 11.4201
R433 in2.n15 in2.n14 11.0809
R434 in2.n28 in2.n26 11.0809
R435 in2.n20 in2.n7 10.5571
R436 in2.n13 in2.n12 10.4505
R437 in2.n13 in2.n4 8.32713
R438 in2.n0 in2.n23 8.08665
R439 in2.n18 in2.n17 7.98904
R440 in2.n31 in2.t0 6.40912
R441 in2.n0 in2.n31 6.3005
R442 in2.n14 in2.n13 5.73172
R443 in2 in2.n20 5.4467
R444 in2.n23 in2.n22 5.2005
R445 in2.n3 in2.n16 3.6505
R446 in2 in2.t6 6.8844
R447 in2.n14 in2.n10 3.1505
R448 in2.n11 in2.n10 3.1505
R449 in2.n12 in2.t4 3.1505
R450 in2.n26 in2.n25 3.1505
R451 in2.n24 in2.n6 87.9163
R452 in2.n19 in2.n18 2.93326
R453 in2.n2 in2.n1 4.36705
R454 in2.t0 in2.n5 0.161734
R455 in2.t4 in2.n4 2.1221
R456 in2.n16 in2.n8 2.05927
R457 in2.n6 in2.n25 0.106663
R458 in2.n10 in2.t4 1.7505
R459 in2.n10 in2.n9 1.7505
R460 in2.n27 in2.n25 1.7505
R461 in2.t4 in2.n2 0.0747233
R462 in2.n19 in2.n1 1.62981
R463 in2.n31 in2.n24 1.62981
R464 in2.n5 in2.n24 3.93332
R465 in2.n17 in2.n3 1.75297
R466 in2 in2.n0 1.68206
R467 in2.n3 in2.n2 1.48126
R468 in2.n7 in2.t1 1.41684
R469 in2.n7 in2.t2 1.41684
R470 in2.n22 in2.t5 1.41684
R471 in2.n22 in2.t3 1.41684
R472 in2.n30 in2.n29 1.32827
R473 CLKb.n9 CLKb.t2 50.9005
R474 CLKb.n5 CLKb.t4 40.1505
R475 CLKb.n2 CLKb.n10 32.5888
R476 CLKb.n5 CLKb.t5 19.2934
R477 CLKb.n10 CLKb.n9 16.9387
R478 CLKb CLKb.n3 11.3091
R479 CLKb.n6 CLKb.n5 11.1192
R480 CLKb.n9 CLKb.n0 11.9058
R481 CLKb.n6 CLKb.t3 12.0388
R482 CLKb.n3 CLKb.n0 3.31861
R483 CLKb CLKb.n8 5.20282
R484 CLKb.n10 CLKb.n4 3.6505
R485 CLKb.n8 CLKb.n7 3.02537
R486 CLKb.n2 CLKb.n0 0.0474974
R487 CLKb.n1 CLKb.t2 0.459182
R488 CLKb.n1 CLKb.n4 0.825727
R489 CLKb.n7 CLKb.t0 1.41684
R490 CLKb.n7 CLKb.t1 1.41684
R491 CLKb.n8 CLKb.n6 1.2213
R492 CLKb.n3 CLKb.t2 5.88322
R493 CLKb.n3 CLKb.n4 1.7588
R494 CLKb.n2 CLKb.n1 1.57306
C0 VDD CLK 0.58708f
C1 a_913_203r# in2 0.1082f
C2 D a_913_203r# 0.13857f
C3 VDD a_2849_203r# 0.79864f
C4 CLKN CLK 0.48557f
C5 a_2849_203r# Q 0.46235f
C6 a_2849_203r# out2 0.56903f
C7 D in2 0.10566f
C8 VDD in2 0.53702f
C9 VDD D 0.3308f
C10 out2 in2 1.31587f
C11 VDD Q 0.53846f
C12 VDD out2 1.23165f
C13 CLKb in2 1.02589f
C14 CLKN in2 0.75776f
C15 D CLKb 0.44498f
C16 VDD CLKb 0.88467f
C17 CLKN D 0.56888f
C18 VDD CLKN 1.29288f
C19 out2 CLKb 0.55873f
C20 CLKN out2 0.7722f
C21 CLKN CLKb 1.51495f
C22 out2 a_2091_203r# 0.39622f
C23 Q VSS 0.84039f
C24 D VSS 1.07258f
C25 CLK VSS 1.05186f
C26 VDD VSS 10.21504f
C27 a_2091_203r# VSS 0.62323f
C28 a_913_203r# VSS 0.5104f
C29 out2 VSS 0.26549f
C30 in2 VSS 1.42201f
C31 CLKb VSS 1.14352f
C32 CLKb.n2 VSS 0.13231f
C33 CLKb.n5 VSS 0.18336f
C34 CLKb.n6 VSS 1.31256f
C35 CLKb.t1 VSS 0.6383f
C36 CLKb.n7 VSS 0.16043f
C37 CLKb.n8 VSS 0.39744f
C38 CLKb.n9 VSS 0.12263f
C39 CLKb.n10 VSS 0.18003f
C40 in2.n0 VSS 0.48802f
C41 in2.t4 VSS 0.49749f
C42 in2.t0 VSS 0.2629f
C43 in2.n7 VSS 0.15999f
C44 in2.n20 VSS 0.53405f
C45 in2.n21 VSS 0.16416f
C46 in2.t3 VSS 0.15707f
C47 in2.t5 VSS 0.12851f
C48 in2.n22 VSS 0.1078f
C49 in2.n23 VSS 0.38254f
C50 a_828_987.t3 VSS 0.15996f
C51 a_828_987.t0 VSS 0.37143f
C52 a_828_987.t1 VSS 0.33714f
C53 a_828_987.n0 VSS 0.76106f
C54 a_828_987.n1 VSS 0.17069f
C55 a_828_987.t2 VSS 0.16228f
C56 a_2044_987.t0 VSS 0.254f
C57 a_2044_987.n0 VSS 0.16162f
C58 a_2044_987.n1 VSS 0.72062f
C59 a_2044_987.t2 VSS 0.25502f
C60 VSS.t6 VSS 0.28924f
C61 VSS.t12 VSS 0.18599f
C62 VSS.t15 VSS 0.27789f
C63 VSS.t4 VSS 0.26549f
C64 VDD.n0 VSS 0.62707f
C65 VDD.n2 VSS 0.10682f
C66 VDD.n26 VSS 0.13268f
C67 VDD.n29 VSS 0.13268f
C68 VDD.t8 VSS 0.2928f
C69 VDD.t18 VSS 0.57327f
C70 VDD.n33 VSS 0.12061f
C71 VDD.n41 VSS 0.16886f
C72 VDD.t24 VSS 0.11045f
C73 VDD.n44 VSS 0.16886f
C74 VDD.t3 VSS 0.59948f
C75 VDD.n54 VSS 0.12061f
C76 VDD.t21 VSS 0.16886f
C77 VDD.n57 VSS 0.12061f
C78 VDD.n58 VSS 0.12061f
C79 VDD.n61 VSS 0.16886f
C80 VDD.n62 VSS 0.12061f
C81 VDD.n63 VSS 0.12061f
C82 VDD.n66 VSS 0.10855f
C83 VDD.n67 VSS 0.12061f
C84 VDD.n68 VSS 0.10855f
C85 VDD.n71 VSS 0.10855f
C86 VDD.n72 VSS 0.12061f
C87 VDD.n73 VSS 0.10855f
C88 VDD.n76 VSS 0.10855f
C89 VDD.n77 VSS 0.12061f
C90 VDD.n78 VSS 0.10855f
C91 VDD.n81 VSS 0.12061f
C92 VDD.n82 VSS 0.12061f
C93 VDD.n83 VSS 0.16886f
C94 VDD.n86 VSS 0.12061f
C95 VDD.n87 VSS 0.12061f
C96 VDD.t7 VSS 0.16886f
C97 VDD.n91 VSS 0.26837f
C98 VDD.n92 VSS 0.15679f
C99 VDD.n93 VSS 0.15679f
C100 VDD.n94 VSS 0.22012f
C101 D.n0 VSS 0.34592f
C102 Q.t1 VSS 0.30633f
C103 Q.t0 VSS 0.32535f
C104 Q.n7 VSS 0.11209f
.ends
