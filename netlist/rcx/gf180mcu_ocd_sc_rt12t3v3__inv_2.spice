* NGSPICE file created from gf180mcu_ocd_sc_rt12t3v3__inv_2.ext - technology: gf180mcuD

.subckt gf180mcu_ocd_sc_rt12t3v3__inv_2 A Y VDD VSS
X0 Y.t3 A.t4 VDD.t1 VDD.t0 pfet_03v3 ad=0.4459p pd=2.235u as=0.7546p ps=4.31u w=1.715u l=0.28u
X1 Y.t2 A.t0 VSS.t3 VSS.t2 nfet_03v3 ad=0.3087p pd=2.01u as=2.75995p ps=14.36u w=1.02u l=0.28u
X2 Y.t4 A.t1 VSS.t1 VSS.t0 nfet_03v3 ad=0.3087p pd=2.01u as=2.75995p ps=14.36u w=1.02u l=0.28u
X3 VDD.t3 A.t3 Y.t0 VDD.t2 pfet_03v3 ad=0.4459p pd=2.235u as=0.4459p ps=2.235u w=1.715u l=0.28u
X4 Y.t1 A.t2 VDD.t5 VDD.t4 pfet_03v3 ad=0.7546p pd=4.31u as=0.4459p ps=2.235u w=1.715u l=0.28u
R0 Y.n12 Y.t2 50.9005
R1 Y.n10 Y.t4 50.9005
R2 Y.n5 Y.n13 32.5888
R3 Y.n2 Y.n11 32.5888
R4 Y.n13 Y.n12 19.8599
R5 Y.n11 Y.n10 16.9387
R6 Y.n12 Y.n3 11.9058
R7 Y.n10 Y.n0 11.9058
R8 Y Y.n7 6.9305
R9 Y Y.n6 6.3005
R10 Y.n6 Y.n3 3.31861
R11 Y.n7 Y.n0 3.31861
R12 Y.n13 Y.n8 3.6505
R13 Y.n11 Y.n9 3.6505
R14 Y.n15 Y.t1 3.22941
R15 Y.n15 Y.n14 2.79036
R16 Y.n5 Y.n3 0.0474974
R17 Y.n2 Y.n0 0.0474974
R18 Y.n4 Y.t2 0.459182
R19 Y.n1 Y.t4 0.459182
R20 Y.n4 Y.n8 0.825727
R21 Y.n1 Y.n9 0.825727
R22 Y.n14 Y.t3 1.06172
R23 Y.n14 Y.t0 1.06172
R24 Y.n6 Y.t2 5.88322
R25 Y.n7 Y.t4 5.88322
R26 Y.n7 Y.n9 1.7588
R27 Y.n6 Y.n8 1.7588
R28 Y.n5 Y.n4 1.57306
R29 Y.n2 Y.n1 1.57306
R30 Y Y.n15 1.22536
R31 A.n4 A.t2 45.7559
R32 A.n10 A.n9 31.8079
R33 A.n5 A.t4 24.8987
R34 A.n4 A.t3 24.8987
R35 A.n5 A.n4 20.8576
R36 A.n0 A.n8 14.4346
R37 A.n8 A.n7 13.4728
R38 A.n7 A.t0 4.05023
R39 A.n7 A.n1 14.5034
R40 A A.n5 9.85239
R41 A.n1 A.n2 10.1236
R42 A.n10 A.t1 5.85149
R43 A.n11 A.n2 5.22251
R44 A.n9 A.n6 5.1705
R45 A.n9 A.n3 4.97699
R46 A.t0 A.n6 31.1087
R47 A.n3 A.t1 4.59773
R48 A.n0 A.n3 4.80413
R49 A A.n11 3.08391
R50 A.n0 A.n1 0.571533
R51 A.t1 A.n2 1.88705
R52 A.n11 A.n10 1.09942
R53 A.n8 A.n6 1.09661
R54 VDD.n32 VDD.n31 137.088
R55 VDD.n22 VDD.n21 137.088
R56 VDD.n20 VDD.n16 137.088
R57 VDD.n28 VDD.n16 137.088
R58 VDD.n32 VDD.t0 117.504
R59 VDD.n30 VDD.n29 106.671
R60 VDD.n23 VDD.t2 97.9197
R61 VDD.n23 VDD.t4 97.9197
R62 VDD.t2 VDD.n22 39.1682
R63 VDD.t4 VDD.n20 39.1682
R64 VDD.n21 VDD.t0 19.5843
R65 VDD.n2 VDD.n15 5.514
R66 VDD.n34 VDD.n33 9.8005
R67 VDD.n33 VDD.n6 2.75725
R68 VDD.n19 VDD.n8 9.8005
R69 VDD.n24 VDD.n19 9.8005
R70 VDD.n4 VDD.n3 2.75725
R71 VDD.n25 VDD.n3 9.8005
R72 VDD.n27 VDD.n5 2.75725
R73 VDD.n13 VDD.n10 9.8005
R74 VDD.n12 VDD.n11 9.8005
R75 VDD.n27 VDD.n26 6.6505
R76 VDD VDD.n34 6.3005
R77 VDD.n33 VDD.n32 6.3005
R78 VDD.n6 VDD 1.77287
R79 VDD.n21 VDD.n8 6.3005
R80 VDD.n6 VDD.n8 2.75725
R81 VDD.n22 VDD.n19 6.3005
R82 VDD.n19 VDD.n1 6.3005
R83 VDD.n24 VDD.n23 6.3005
R84 VDD.n4 VDD.n24 2.75725
R85 VDD.n20 VDD.n3 6.3005
R86 VDD.n1 VDD.n4 1.77287
R87 VDD.n25 VDD.n16 6.3005
R88 VDD.n25 VDD.n5 2.75725
R89 VDD.n28 VDD.n27 6.3005
R90 VDD.n5 VDD.n1 1.77287
R91 VDD.n29 VDD.n28 6.3005
R92 VDD.n2 VDD.n1 1.77287
R93 VDD.n26 VDD.n1 6.3005
R94 VDD.n11 VDD 6.3005
R95 VDD VDD.n12 6.3005
R96 VDD VDD.n13 6.3005
R97 VDD.n31 VDD.n10 6.3005
R98 VDD.n31 VDD.n30 6.3005
R99 VDD.n15 VDD.n0 5.4873
R100 VDD VDD.t1 3.19028
R101 VDD.n29 VDD.n0 2.82549
R102 VDD.n30 VDD.n14 2.82549
R103 VDD.n26 VDD.n17 2.75725
R104 VDD.n2 VDD.n17 5.514
R105 VDD.n13 VDD.n9 2.75725
R106 VDD.n12 VDD.n9 2.75725
R107 VDD.n14 VDD.n10 2.73055
R108 VDD.n11 VDD.n7 2.17736
R109 VDD.n34 VDD.n7 2.17736
R110 VDD.n1 VDD.n18 2.13688
R111 VDD.n31 VDD.n7 2.06282
R112 VDD.n1 VDD.n0 2.03587
R113 VDD.n14 VDD 2.03587
R114 VDD.n28 VDD.n15 1.77287
R115 VDD.n28 VDD.n17 1.77287
R116 VDD.n31 VDD.n9 1.77287
R117 VDD.n1 VDD 1.6685
R118 VDD.n18 VDD.t3 1.06172
R119 VDD.n18 VDD.t5 1.06172
R120 VSS.n29 VSS.n28 513.399
R121 VSS.n14 VSS.n13 513.399
R122 VSS.n18 VSS.n14 513.399
R123 VSS.n20 VSS.n19 513.399
R124 VSS.n20 VSS.n11 513.399
R125 VSS.n19 VSS.t2 352.962
R126 VSS.n13 VSS.t0 288.788
R127 VSS.n29 VSS.t0 224.613
R128 VSS.t2 VSS.n18 160.438
R129 VSS.n26 VSS.n25 131.357
R130 VSS.n30 VSS.n10 10.8894
R131 VSS.n21 VSS.n8 2.65917
R132 VSS.n9 VSS.n7 2.62326
R133 VSS.n21 VSS.n2 9.44628
R134 VSS.n17 VSS.n2 9.10893
R135 VSS.n0 VSS.n7 8.60291
R136 VSS.n3 VSS.n10 7.38939
R137 VSS.n22 VSS.n12 7.38939
R138 VSS VSS.n26 5.41963
R139 VSS.n25 VSS 5.41963
R140 VSS.n30 VSS.n29 5.2005
R141 VSS.n1 VSS.n30 3.00607
R142 VSS.n28 VSS.n10 5.2005
R143 VSS.n10 VSS 5.2005
R144 VSS.n7 VSS.n14 5.2005
R145 VSS VSS.n9 1.28987
R146 VSS.n13 VSS.n0 5.2005
R147 VSS.n1 VSS 0.552811
R148 VSS.n19 VSS.n2 5.2005
R149 VSS.n18 VSS.n17 5.2005
R150 VSS.n17 VSS.n9 2.62326
R151 VSS.n12 VSS.n11 5.2005
R152 VSS.n8 VSS.n12 2.65917
R153 VSS.n21 VSS.n20 5.2005
R154 VSS VSS.n8 1.27192
R155 VSS.n6 VSS 1.27115
R156 VSS.n23 VSS.n6 5.32092
R157 VSS.n22 VSS 5.2005
R158 VSS VSS.n3 5.2005
R159 VSS VSS.n5 1.27115
R160 VSS.n2 VSS.t3 4.4105
R161 VSS.n0 VSS.t1 4.4105
R162 VSS.n2 VSS.n15 2.7725
R163 VSS.n0 VSS.n16 2.7725
R164 VSS.n26 VSS.n4 2.66071
R165 VSS.n25 VSS.n24 2.66071
R166 VSS.n27 VSS.n3 2.66071
R167 VSS.n27 VSS.n5 5.32092
R168 VSS.n5 VSS.n4 5.32092
R169 VSS.n23 VSS.n22 2.66071
R170 VSS.n24 VSS.n6 5.32092
R171 VSS VSS.n2 2.34249
R172 VSS.n1 VSS.n0 1.92998
R173 VSS.n24 VSS.n11 1.27115
R174 VSS.n23 VSS.n11 1.27115
R175 VSS.n28 VSS.n27 1.27115
R176 VSS.n28 VSS.n4 1.27115
C0 VDD A 0.55183f
C1 VDD Y 0.55247f
C2 A Y 0.37224f
C3 Y VSS 0.43485f
C4 A VSS 1.03032f
C5 VDD VSS 2.8595f
C6 VDD.n28 VSS 0.12712f
C7 VDD.n31 VSS 0.12712f
C8 A.n10 VSS 0.1147f
C9 Y.t1 VSS 0.11559f
C10 Y.n15 VSS 0.21595f
.ends
