* NGSPICE file created from gf180mcu_ocd_sc_rt12t3v3__inv_2.ext - technology: gf180mcuD

.subckt gf180mcu_ocd_sc_rt12t3v3__inv_2 A Y VDD VSS
X0 Y.t4 A.t4 VDD.t1 VDD.t0 pfet_03v3 ad=0.4459p pd=2.235u as=0.7546p ps=4.31u w=1.715u l=0.28u
X1 Y.t1 A.t0 VSS.t3 VSS.t2 nfet_03v3 ad=0.3087p pd=2.01u as=2.75995p ps=14.36u w=1.02u l=0.28u
X2 Y.t0 A.t1 VSS.t1 VSS.t0 nfet_03v3 ad=0.3087p pd=2.01u as=2.75995p ps=14.36u w=1.02u l=0.28u
X3 VDD.t3 A.t3 Y.t2 VDD.t2 pfet_03v3 ad=0.4459p pd=2.235u as=0.4459p ps=2.235u w=1.715u l=0.28u
X4 Y.t3 A.t2 VDD.t5 VDD.t4 pfet_03v3 ad=0.7546p pd=4.31u as=0.4459p ps=2.235u w=1.715u l=0.28u
R0 Y.n2 Y.n0 3.37947
R1 Y Y.n0 6.88006
R2 Y.t1 Y.n0 0.645433
R3 Y.t0 Y.n1 3.32853
R4 Y.n4 Y.t3 3.22941
R5 Y.n4 Y.n3 2.79036
R6 Y Y.t0 7.63295
R7 Y Y.n4 1.22536
R8 Y.n3 Y.t4 1.06172
R9 Y.n3 Y.t2 1.06172
R10 A.n14 A.n8 102.201
R11 A.n3 A.n2 2.02776
R12 A.n8 A.n2 54.7505
R13 A.n4 A.t2 45.7559
R14 A.n15 A.n6 39.73
R15 A.n5 A.t4 24.8987
R16 A.n4 A.t3 24.8987
R17 A.n5 A.n4 20.8576
R18 A.n11 A.n7 13.4391
R19 A A.n5 9.85239
R20 A.n17 A.n16 37.1992
R21 A.n14 A.n13 9.78914
R22 A.n1 A.n6 2.48555
R23 A.n13 A.n9 5.60586
R24 A.n13 A.n12 5.4755
R25 A.n0 A.n14 4.81186
R26 A.n13 A.n7 4.48005
R27 A.t1 A.n0 4.12886
R28 A.t0 A.n10 3.6505
R29 A.n3 A.n9 40.4776
R30 A.n12 A.n10 3.6505
R31 A.n0 A.n1 0.334331
R32 A.n10 A.n3 38.1441
R33 A.n17 A.n6 2.98998
R34 A.n15 A.t1 2.73523
R35 A.n16 A.n7 2.49399
R36 A.n16 A.n15 2.39411
R37 A.n11 A.t0 2.08621
R38 A.n12 A.n11 2.08621
R39 A.n9 A.n8 1.95586
R40 A.n1 A.n2 3.41032
R41 A A.n17 3.08391
R42 VDD.n32 VDD.n31 137.088
R43 VDD.n22 VDD.n21 137.088
R44 VDD.n20 VDD.n16 137.088
R45 VDD.n28 VDD.n16 137.088
R46 VDD.n32 VDD.t0 117.504
R47 VDD.n30 VDD.n29 106.671
R48 VDD.n23 VDD.t2 97.9197
R49 VDD.n23 VDD.t4 97.9197
R50 VDD.t2 VDD.n22 39.1682
R51 VDD.t4 VDD.n20 39.1682
R52 VDD.n21 VDD.t0 19.5843
R53 VDD.n2 VDD.n15 5.514
R54 VDD.n34 VDD.n33 9.8005
R55 VDD.n33 VDD.n6 2.75725
R56 VDD.n19 VDD.n8 9.8005
R57 VDD.n24 VDD.n19 9.8005
R58 VDD.n4 VDD.n3 2.75725
R59 VDD.n25 VDD.n3 9.8005
R60 VDD.n27 VDD.n5 2.75725
R61 VDD.n13 VDD.n10 9.8005
R62 VDD.n12 VDD.n11 9.8005
R63 VDD.n27 VDD.n26 6.6505
R64 VDD VDD.n34 6.3005
R65 VDD.n33 VDD.n32 6.3005
R66 VDD.n6 VDD 1.77287
R67 VDD.n21 VDD.n8 6.3005
R68 VDD.n6 VDD.n8 2.75725
R69 VDD.n22 VDD.n19 6.3005
R70 VDD.n19 VDD.n1 6.3005
R71 VDD.n24 VDD.n23 6.3005
R72 VDD.n4 VDD.n24 2.75725
R73 VDD.n20 VDD.n3 6.3005
R74 VDD.n1 VDD.n4 1.77287
R75 VDD.n25 VDD.n16 6.3005
R76 VDD.n25 VDD.n5 2.75725
R77 VDD.n28 VDD.n27 6.3005
R78 VDD.n5 VDD.n1 1.77287
R79 VDD.n29 VDD.n28 6.3005
R80 VDD.n2 VDD.n1 1.77287
R81 VDD.n26 VDD.n1 6.3005
R82 VDD.n11 VDD 6.3005
R83 VDD VDD.n12 6.3005
R84 VDD VDD.n13 6.3005
R85 VDD.n31 VDD.n10 6.3005
R86 VDD.n31 VDD.n30 6.3005
R87 VDD.n15 VDD.n0 5.4873
R88 VDD VDD.t1 3.19028
R89 VDD.n29 VDD.n0 2.82549
R90 VDD.n30 VDD.n14 2.82549
R91 VDD.n26 VDD.n17 2.75725
R92 VDD.n2 VDD.n17 5.514
R93 VDD.n13 VDD.n9 2.75725
R94 VDD.n12 VDD.n9 2.75725
R95 VDD.n14 VDD.n10 2.73055
R96 VDD.n11 VDD.n7 2.17736
R97 VDD.n34 VDD.n7 2.17736
R98 VDD.n1 VDD.n18 2.13688
R99 VDD.n31 VDD.n7 2.06282
R100 VDD.n1 VDD.n0 2.03587
R101 VDD.n14 VDD 2.03587
R102 VDD.n28 VDD.n15 1.77287
R103 VDD.n28 VDD.n17 1.77287
R104 VDD.n31 VDD.n9 1.77287
R105 VDD.n1 VDD 1.6685
R106 VDD.n18 VDD.t3 1.06172
R107 VDD.n18 VDD.t5 1.06172
R108 VSS.n29 VSS.n28 513.399
R109 VSS.n14 VSS.n13 513.399
R110 VSS.n18 VSS.n14 513.399
R111 VSS.n20 VSS.n19 513.399
R112 VSS.n20 VSS.n11 513.399
R113 VSS.n19 VSS.t2 352.962
R114 VSS.n13 VSS.t0 288.788
R115 VSS.n29 VSS.t0 224.613
R116 VSS.t2 VSS.n18 160.438
R117 VSS.n26 VSS.n25 131.357
R118 VSS.n30 VSS.n10 10.8894
R119 VSS.n21 VSS.n8 2.65917
R120 VSS.n17 VSS.n9 2.62326
R121 VSS.n21 VSS.n2 9.44628
R122 VSS.n17 VSS.n2 9.10893
R123 VSS.n0 VSS.n7 8.60291
R124 VSS.n3 VSS.n10 7.38939
R125 VSS.n22 VSS.n12 7.38939
R126 VSS VSS.n26 5.41963
R127 VSS.n25 VSS 5.41963
R128 VSS.n30 VSS.n29 5.2005
R129 VSS.n1 VSS.n30 3.00607
R130 VSS.n28 VSS.n10 5.2005
R131 VSS.n10 VSS 5.2005
R132 VSS.n7 VSS.n14 5.2005
R133 VSS.n9 VSS.n7 2.62326
R134 VSS.n13 VSS.n0 5.2005
R135 VSS.n1 VSS 0.552811
R136 VSS.n19 VSS.n2 5.2005
R137 VSS.n18 VSS.n17 5.2005
R138 VSS.n9 VSS 1.28987
R139 VSS.n12 VSS.n11 5.2005
R140 VSS.n8 VSS.n12 2.65917
R141 VSS.n21 VSS.n20 5.2005
R142 VSS VSS.n8 1.27192
R143 VSS.n6 VSS 1.27115
R144 VSS.n23 VSS.n6 5.32092
R145 VSS.n22 VSS 5.2005
R146 VSS VSS.n3 5.2005
R147 VSS VSS.n5 1.27115
R148 VSS.n2 VSS.n15 4.5995
R149 VSS.n0 VSS.n16 4.5995
R150 VSS.n2 VSS.t3 4.4105
R151 VSS.n0 VSS.t1 4.4105
R152 VSS.n26 VSS.n4 2.66071
R153 VSS.n25 VSS.n24 2.66071
R154 VSS.n27 VSS.n3 2.66071
R155 VSS.n27 VSS.n5 5.32092
R156 VSS.n5 VSS.n4 5.32092
R157 VSS.n23 VSS.n22 2.66071
R158 VSS.n24 VSS.n6 5.32092
R159 VSS VSS.n2 2.34249
R160 VSS.n1 VSS.n0 1.92998
R161 VSS.n24 VSS.n11 1.27115
R162 VSS.n23 VSS.n11 1.27115
R163 VSS.n28 VSS.n27 1.27115
R164 VSS.n28 VSS.n4 1.27115
C0 Y VDD 0.92303f
C1 VDD A 0.58074f
C2 Y A 0.50239f
C3 Y VSS 0.71246f
C4 A VSS 1.10205f
C5 VDD VSS 2.89444f
C6 VDD.n1 VSS 0.12055f
C7 VDD.n16 VSS 0.10892f
C8 VDD.n28 VSS 0.17311f
C9 VDD.n31 VSS 0.17311f
C10 VDD.n32 VSS 0.10114f
C11 A.n17 VSS 0.16111f
C12 Y.t0 VSS 0.12679f
C13 Y.n1 VSS 0.13167f
C14 Y.n2 VSS 0.14122f
C15 Y.t3 VSS 0.13196f
C16 Y.n3 VSS 0.13617f
C17 Y.n4 VSS 0.34584f
.ends
