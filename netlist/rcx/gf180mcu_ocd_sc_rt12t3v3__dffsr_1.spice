* NGSPICE file created from gf180mcu_ocd_sc_rt12t3v3__dffsr_1.ext - technology: gf180mcuD

.subckt gf180mcu_ocd_sc_rt12t3v3__dffsr_1 D CLK SN RN Q QN VDD VSS
X0 R.t1 RN.t2 VDD.t3 VDD.t2 pfet_03v3 ad=0.3341p pd=1.805u as=0.3341p ps=1.805u w=1.285u l=0.28u
X1 in1.t3 CLKb a_4039_203r# VSS.t20 nfet_03v3 ad=0.3087p pd=2.01u as=0.52065p ps=3.23u w=1.02u l=0.28u
X2 in1.t0 CLKN a_2065_203r# VSS.t18 nfet_03v3 ad=0.3087p pd=2.01u as=0.52065p ps=3.23u w=1.02u l=0.28u
X3 a_4039_203r# out1 VSS.t23 VSS.t22 nfet_03v3 ad=0.3087p pd=2.01u as=2.74793p ps=14.86u w=1.02u l=0.28u
X4 QN.t2 out2 VSS.t15 VSS.t14 nfet_03v3 ad=0.3087p pd=2.01u as=2.74793p ps=14.86u w=1.02u l=0.28u
X5 VDD.t53 CLK.t1 CLKN VDD.t52 pfet_03v3 ad=0.3341p pd=1.805u as=0.3341p ps=1.805u w=1.285u l=0.28u
X6 a_3938_987.t3 out1 VDD.t47 VDD.t46 pfet_03v3 ad=0.3341p pd=1.805u as=0.3341p ps=1.805u w=1.285u l=0.28u
X7 a_5474_987.t0 R.t5 out2 VDD.t4 pfet_03v3 ad=0.5654p pd=3.45u as=0.3341p ps=1.805u w=1.285u l=0.28u
X8 VDD.t23 out2 a_6694_987.t0 VDD.t22 pfet_03v3 ad=0.3341p pd=1.805u as=0.5654p ps=3.45u w=1.285u l=0.28u
X9 a_4706_987.t3 out1 VDD.t49 VDD.t48 pfet_03v3 ad=0.3341p pd=1.805u as=0.3341p ps=1.805u w=1.285u l=0.28u
X10 a_2065_203r# D.t0 VSS.t33 VSS.t32 nfet_03v3 ad=0.3087p pd=2.01u as=2.9769p ps=16.1u w=1.02u l=0.28u
X11 out1 SNb a_2824_203r# VSS.t10 nfet_03v3 ad=0.3087p pd=2.01u as=0.52065p ps=3.23u w=1.02u l=0.28u
X12 VDD.t69 D.t2 a_1948_987.t2 VDD.t68 pfet_03v3 ad=0.3341p pd=1.805u as=0.5654p ps=3.45u w=1.285u l=0.28u
X13 VDD.t17 SNb a_2717_987.t1 VDD.t16 pfet_03v3 ad=0.3341p pd=1.805u as=0.5654p ps=3.45u w=1.285u l=0.28u
X14 a_1948_987.t1 CLKb in1.t5 VDD.t39 pfet_03v3 ad=0.5654p pd=3.45u as=0.3341p ps=1.805u w=1.285u l=0.28u
X15 a_2717_987.t3 R.t7 out1 VDD.t59 pfet_03v3 ad=0.5654p pd=3.45u as=0.3341p ps=1.805u w=1.285u l=0.28u
X16 VDD.t10 SN.t1 a_921_203r# VDD.t9 pfet_03v3 ad=0.3341p pd=1.805u as=0.3341p ps=1.805u w=1.285u l=0.28u
X17 in2.t0 CLKN a_4706_987.t1 VDD.t36 pfet_03v3 ad=0.3341p pd=1.805u as=0.3341p ps=1.805u w=1.285u l=0.28u
X18 VDD.t29 out2 QN.t0 VDD.t28 pfet_03v3 ad=0.3341p pd=1.805u as=0.3341p ps=1.805u w=1.285u l=0.28u
X19 a_6795_203r# out2 VSS.t13 VSS.t12 nfet_03v3 ad=0.3087p pd=2.01u as=2.74793p ps=14.86u w=1.02u l=0.28u
X20 a_1948_987.t3 D.t1 VDD.t71 VDD.t70 pfet_03v3 ad=0.3341p pd=1.805u as=0.3341p ps=1.805u w=1.285u l=0.28u
X21 SNb a_921_203r# VSS.t29 VSS.t28 nfet_03v3 ad=0.3087p pd=2.01u as=2.9769p ps=16.1u w=1.02u l=0.28u
X22 a_2824_203r# in1.t6 VSS.t35 VSS.t34 nfet_03v3 ad=0.3087p pd=2.015u as=2.9769p ps=16.1u w=1.02u l=0.28u
X23 VDD.t61 in1.t8 a_2717_987.t4 VDD.t60 pfet_03v3 ad=0.3341p pd=1.805u as=0.5654p ps=3.45u w=1.285u l=0.28u
X24 VDD.t15 SNb a_5474_987.t3 VDD.t14 pfet_03v3 ad=0.3341p pd=1.805u as=0.5654p ps=3.45u w=1.285u l=0.28u
X25 CLKN CLK.t0 VSS.t27 VSS.t26 nfet_03v3 ad=0.3087p pd=2.01u as=2.9769p ps=16.1u w=1.02u l=0.28u
X26 SNb a_921_203r# VDD.t55 VDD.t54 pfet_03v3 ad=0.3341p pd=1.805u as=0.3341p ps=1.805u w=1.285u l=0.28u
X27 VDD.t1 RN.t1 R.t2 VDD.t0 pfet_03v3 ad=0.5654p pd=3.45u as=0.3341p ps=1.805u w=1.285u l=0.28u
X28 a_4706_987.t0 CLKN in2.t1 VDD.t37 pfet_03v3 ad=0.5654p pd=3.45u as=0.3341p ps=1.805u w=1.285u l=0.28u
X29 VDD.t6 in2.t8 a_5474_987.t1 VDD.t5 pfet_03v3 ad=0.3341p pd=1.805u as=0.5654p ps=3.45u w=1.285u l=0.28u
X30 Q.t0 QN.t5 VDD.t65 VDD.t64 pfet_03v3 ad=0.3341p pd=1.805u as=0.3341p ps=1.805u w=1.285u l=0.28u
X31 a_5574_203r# in2.t6 VSS.t9 VSS.t8 nfet_03v3 ad=0.3087p pd=2.015u as=2.9769p ps=16.1u w=1.02u l=0.28u
X32 CLKb CLKN VDD.t31 VDD.t30 pfet_03v3 ad=0.3341p pd=1.805u as=0.3341p ps=1.805u w=1.285u l=0.28u
X33 a_5474_987.t4 SNb VDD.t21 VDD.t20 pfet_03v3 ad=0.3341p pd=1.805u as=0.3341p ps=1.805u w=1.285u l=0.28u
X34 a_2717_987.t5 in1.t7 VDD.t63 VDD.t62 pfet_03v3 ad=0.5654p pd=3.45u as=0.3341p ps=1.805u w=1.285u l=0.28u
X35 in1.t1 CLKN a_3938_987.t0 VDD.t34 pfet_03v3 ad=0.3341p pd=1.805u as=0.3341p ps=1.805u w=1.285u l=0.28u
X36 a_6694_987.t1 out2 VDD.t25 VDD.t24 pfet_03v3 ad=0.3341p pd=1.805u as=0.3341p ps=1.805u w=1.285u l=0.28u
X37 out2 SNb a_5574_203r# VSS.t11 nfet_03v3 ad=0.3087p pd=2.01u as=0.52065p ps=3.23u w=1.02u l=0.28u
X38 a_2717_987.t2 SNb VDD.t19 VDD.t18 pfet_03v3 ad=0.3341p pd=1.805u as=0.3341p ps=1.805u w=1.285u l=0.28u
X39 VDD.t67 QN.t4 Q.t1 VDD.t66 pfet_03v3 ad=0.5654p pd=3.45u as=0.3341p ps=1.805u w=1.285u l=0.28u
X40 a_921_203r# SN.t0 VSS.t7 VSS.t6 nfet_03v3 ad=0.3087p pd=2.01u as=2.9769p ps=16.1u w=1.02u l=0.28u
X41 Q.t2 QN.t3 VSS.t31 VSS.t30 nfet_03v3 ad=0.3087p pd=2.01u as=2.9769p ps=16.1u w=1.02u l=0.28u
X42 CLKN CLK.t2 VDD.t51 VDD.t50 pfet_03v3 ad=0.3341p pd=1.805u as=0.5654p ps=3.45u w=1.285u l=0.28u
X43 VDD.t33 CLKN CLKb VDD.t32 pfet_03v3 ad=0.5654p pd=3.45u as=0.3341p ps=1.805u w=1.285u l=0.28u
X44 VDD.t45 out1 a_4706_987.t2 VDD.t44 pfet_03v3 ad=0.3341p pd=1.805u as=0.5654p ps=3.45u w=1.285u l=0.28u
X45 in2.t3 CLKb a_6694_987.t3 VDD.t40 pfet_03v3 ad=0.3341p pd=1.805u as=0.3341p ps=1.805u w=1.285u l=0.28u
X46 CLKb CLKN VSS.t17 VSS.t16 nfet_03v3 ad=0.3087p pd=2.01u as=2.9769p ps=16.1u w=1.02u l=0.28u
X47 out1 R.t4 VSS.t5 VSS.t4 nfet_03v3 ad=0.3087p pd=2.01u as=2.74793p ps=14.86u w=1.02u l=0.28u
X48 a_921_203r# SN.t2 VDD.t8 VDD.t7 pfet_03v3 ad=0.3341p pd=1.805u as=0.5654p ps=3.45u w=1.285u l=0.28u
X49 in1.t4 CLKb a_1948_987.t0 VDD.t38 pfet_03v3 ad=0.3341p pd=1.805u as=0.3341p ps=1.805u w=1.285u l=0.28u
X50 out1 R.t8 a_2717_987.t0 VDD.t13 pfet_03v3 ad=0.3341p pd=1.805u as=0.3341p ps=1.805u w=1.285u l=0.28u
X51 in2.t5 CLKb a_4807_203r# VSS.t21 nfet_03v3 ad=0.3087p pd=2.01u as=0.52065p ps=3.23u w=1.02u l=0.28u
X52 VDD.t57 a_921_203r# SNb VDD.t56 pfet_03v3 ad=0.3341p pd=1.805u as=0.3341p ps=1.805u w=1.285u l=0.28u
X53 a_4807_203r# out1 VSS.t25 VSS.t24 nfet_03v3 ad=0.3087p pd=2.01u as=2.74793p ps=14.86u w=1.02u l=0.28u
X54 a_5474_987.t2 in2.t7 VDD.t12 VDD.t11 pfet_03v3 ad=0.5654p pd=3.45u as=0.3341p ps=1.805u w=1.285u l=0.28u
X55 a_6694_987.t2 CLKb in2.t4 VDD.t41 pfet_03v3 ad=0.5654p pd=3.45u as=0.3341p ps=1.805u w=1.285u l=0.28u
X56 QN.t1 out2 VDD.t27 VDD.t26 pfet_03v3 ad=0.3341p pd=1.805u as=0.5654p ps=3.45u w=1.285u l=0.28u
X57 R.t0 RN.t0 VSS.t1 VSS.t0 nfet_03v3 ad=0.3087p pd=2.015u as=2.9769p ps=16.1u w=1.02u l=0.28u
X58 out2 R.t3 VSS.t3 VSS.t2 nfet_03v3 ad=0.3087p pd=2.01u as=2.74793p ps=14.86u w=1.02u l=0.28u
X59 in2.t2 CLKN a_6795_203r# VSS.t19 nfet_03v3 ad=0.3087p pd=2.01u as=0.53235p ps=3.25u w=1.02u l=0.28u
X60 VDD.t43 out1 a_3938_987.t2 VDD.t42 pfet_03v3 ad=0.3341p pd=1.805u as=0.5654p ps=3.45u w=1.285u l=0.28u
X61 a_3938_987.t1 CLKN in1.t2 VDD.t35 pfet_03v3 ad=0.5654p pd=3.45u as=0.3341p ps=1.805u w=1.285u l=0.28u
X62 out2 R.t6 a_5474_987.t5 VDD.t58 pfet_03v3 ad=0.3341p pd=1.805u as=0.3341p ps=1.805u w=1.285u l=0.28u
R0 Q.t2 Q.n1 3.32853
R1 Q Q.n0 2.92662
R2 Q.n0 Q.t0 1.41684
R3 Q.n0 Q.t1 1.41684
R4 Q Q.t2 7.28055
R5 QN.n1 QN.t4 41.6424
R6 QN.n1 QN.t5 38.1951
R7 QN QN.n1 4.18637
R8 QN.t2 QN.n2 3.32853
R9 QN QN.t3 6.08857
R10 QN.n0 QN.t1 1.41684
R11 QN.n0 QN.t0 1.41684
R12 QN QN.t2 7.38701
R13 QN QN.n0 3.91966
R14 D.n0 D.t1 31.3586
R15 D.n0 D.t2 23.4503
R16 D D.n0 13.8634
R17 D D.t0 6.28719
R18 RN.n7 RN.t1 50.0576
R19 RN.n7 RN.t2 29.2005
R20 RN RN.n7 19.2581
R21 RN.n3 RN.n1 10.5609
R22 RN.n5 RN.n4 9.10659
R23 RN.n6 RN.n1 6.96868
R24 RN.n0 RN.n6 35.6422
R25 RN.n2 RN.n1 3.89383
R26 RN.n0 RN.n4 4.98576
R27 RN RN.n0 4.7107
R28 RN.t0 RN.n2 3.53276
R29 RN.n6 RN.n5 3.52014
R30 RN.n5 RN.n2 2.9205
R31 RN.n3 RN.t0 2.15536
R32 RN.n4 RN.n3 1.13455
R33 SN.n0 SN.t1 49.409
R34 SN.n0 SN.t2 29.1449
R35 SN SN.t0 16.0049
R36 SN SN.n0 11.0962
R37 CLK.n0 CLK.t1 40.1505
R38 CLK CLK.n0 19.9339
R39 CLK.n0 CLK.t2 19.2934
R40 CLK CLK.t0 6.59728
R41 VDD.n205 VDD.n204 1181.11
R42 VDD.n207 VDD.n206 137.088
R43 VDD.n115 VDD.n114 137.088
R44 VDD.n119 VDD.n118 137.088
R45 VDD.n120 VDD.n110 137.088
R46 VDD.n124 VDD.n123 137.088
R47 VDD.t56 VDD.n104 137.088
R48 VDD.n128 VDD.t56 137.088
R49 VDD.n132 VDD.n101 137.088
R50 VDD.n133 VDD.n132 137.088
R51 VDD.n137 VDD.n97 137.088
R52 VDD.n139 VDD.n95 137.088
R53 VDD.n142 VDD.n95 137.088
R54 VDD.n144 VDD.n92 137.088
R55 VDD.n147 VDD.n92 137.088
R56 VDD.n149 VDD.n91 137.088
R57 VDD.n154 VDD.n153 137.088
R58 VDD.n154 VDD.n89 137.088
R59 VDD.n159 VDD.n158 137.088
R60 VDD.n163 VDD.n162 137.088
R61 VDD.n164 VDD.n163 137.088
R62 VDD.n169 VDD.n168 137.088
R63 VDD.n172 VDD.n77 137.088
R64 VDD.n174 VDD.n173 137.088
R65 VDD.n177 VDD.n73 137.088
R66 VDD.n179 VDD.n178 137.088
R67 VDD.n183 VDD.n182 137.088
R68 VDD.n184 VDD.n69 137.088
R69 VDD.n188 VDD.n187 137.088
R70 VDD.n192 VDD.n64 137.088
R71 VDD.n194 VDD.n193 137.088
R72 VDD.n197 VDD.n61 137.088
R73 VDD.n60 VDD.n56 137.088
R74 VDD.n203 VDD.n56 137.088
R75 VDD.t34 VDD.n85 129.744
R76 VDD.t44 VDD.n82 129.744
R77 VDD.t14 VDD.n177 129.744
R78 VDD.n199 VDD.t66 129.744
R79 VDD.t36 VDD.n167 124.847
R80 VDD.t5 VDD.n172 124.847
R81 VDD.n193 VDD.t41 124.847
R82 VDD.n198 VDD.t28 124.847
R83 VDD.n207 VDD.t50 117.504
R84 VDD.n120 VDD.t32 117.504
R85 VDD.n125 VDD.t9 117.504
R86 VDD.n129 VDD.t0 117.504
R87 VDD.n134 VDD.t70 117.504
R88 VDD.n152 VDD.t13 110.159
R89 VDD.n157 VDD.t42 110.159
R90 VDD.n72 VDD.t58 110.159
R91 VDD.n69 VDD.t22 110.159
R92 VDD.t18 VDD.n148 105.263
R93 VDD.n184 VDD.t4 105.263
R94 VDD.n189 VDD.t24 105.263
R95 VDD.t62 VDD.n143 99.1437
R96 VDD.t52 VDD.n113 97.9197
R97 VDD.n113 VDD.t30 97.9197
R98 VDD.n110 VDD.t7 97.9197
R99 VDD.n138 VDD.t38 97.9197
R100 VDD.t39 VDD.n138 97.9197
R101 VDD.n143 VDD.t60 96.6957
R102 VDD.n148 VDD.t16 90.5758
R103 VDD.t37 VDD.n77 90.5758
R104 VDD.t11 VDD.n73 90.5758
R105 VDD.n189 VDD.t40 90.5758
R106 VDD.n194 VDD.t26 90.5758
R107 VDD.t59 VDD.n152 85.6798
R108 VDD.t46 VDD.n157 85.6798
R109 VDD.t20 VDD.n72 85.6798
R110 VDD.n125 VDD.t54 78.3359
R111 VDD.n129 VDD.t2 78.3359
R112 VDD.n134 VDD.t68 78.3359
R113 VDD.n162 VDD.t35 70.9919
R114 VDD.n167 VDD.t48 70.9919
R115 VDD.t64 VDD.n198 70.9919
R116 VDD.n85 VDD.t35 66.096
R117 VDD.n82 VDD.t48 66.096
R118 VDD.n199 VDD.t64 66.096
R119 VDD.t54 VDD.n104 58.752
R120 VDD.t2 VDD.n128 58.752
R121 VDD.t68 VDD.n133 58.752
R122 VDD.n153 VDD.t59 51.4081
R123 VDD.n158 VDD.t46 51.4081
R124 VDD.n179 VDD.t20 51.4081
R125 VDD.t16 VDD.n147 46.5121
R126 VDD.n169 VDD.t37 46.5121
R127 VDD.n174 VDD.t11 46.5121
R128 VDD.t40 VDD.n64 46.5121
R129 VDD.t26 VDD.n61 46.5121
R130 VDD.t60 VDD.n142 40.3922
R131 VDD.n115 VDD.t52 39.1682
R132 VDD.n118 VDD.t30 39.1682
R133 VDD.n123 VDD.t7 39.1682
R134 VDD.t38 VDD.n137 39.1682
R135 VDD.n139 VDD.t39 39.1682
R136 VDD.n144 VDD.t62 37.9442
R137 VDD.n149 VDD.t18 31.8242
R138 VDD.t4 VDD.n183 31.8242
R139 VDD.t24 VDD.n188 31.8242
R140 VDD.n91 VDD.t13 26.9283
R141 VDD.n89 VDD.t42 26.9283
R142 VDD.n182 VDD.t58 26.9283
R143 VDD.n187 VDD.t22 26.9283
R144 VDD.n114 VDD.t50 19.5843
R145 VDD.t32 VDD.n119 19.5843
R146 VDD.t9 VDD.n124 19.5843
R147 VDD.t0 VDD.n101 19.5843
R148 VDD.t70 VDD.n97 19.5843
R149 VDD.n168 VDD.t36 12.2404
R150 VDD.n173 VDD.t5 12.2404
R151 VDD.t41 VDD.n192 12.2404
R152 VDD.t28 VDD.n197 12.2404
R153 VDD.n209 VDD.n208 9.8005
R154 VDD.n208 VDD.n37 2.75725
R155 VDD.n116 VDD.n50 9.8005
R156 VDD.n116 VDD.n111 9.8005
R157 VDD.n117 VDD.n12 2.75725
R158 VDD.n117 VDD.n109 9.8005
R159 VDD.n121 VDD.n36 2.75725
R160 VDD.n121 VDD.n108 9.8005
R161 VDD.n122 VDD.n13 2.75725
R162 VDD.n122 VDD.n107 9.8005
R163 VDD.n126 VDD.n35 2.75725
R164 VDD.n126 VDD.n14 9.8005
R165 VDD.n127 VDD.n14 9.8005
R166 VDD.n40 VDD.n103 2.75725
R167 VDD.n130 VDD.n103 9.8005
R168 VDD.n130 VDD.n102 9.8005
R169 VDD.n44 VDD.n102 2.75725
R170 VDD.n131 VDD.n100 9.8005
R171 VDD.n135 VDD.n100 9.8005
R172 VDD.n135 VDD.n34 2.75725
R173 VDD.n136 VDD.n98 9.8005
R174 VDD.n15 VDD.n96 2.75725
R175 VDD.n140 VDD.n96 9.8005
R176 VDD.n17 VDD.n16 2.75725
R177 VDD.n141 VDD.n16 9.8005
R178 VDD.n141 VDD.n48 9.8005
R179 VDD.n30 VDD.n48 2.75725
R180 VDD.n145 VDD.n93 9.8005
R181 VDD.n10 VDD.n93 2.75725
R182 VDD.n146 VDD.n47 9.8005
R183 VDD.n32 VDD.n47 2.75725
R184 VDD.n150 VDD.n9 9.8005
R185 VDD.n151 VDD.n9 9.8005
R186 VDD.n18 VDD.n88 2.75725
R187 VDD.n155 VDD.n88 9.8005
R188 VDD.n155 VDD.n86 9.8005
R189 VDD.n33 VDD.n86 2.75725
R190 VDD.n156 VDD.n84 9.8005
R191 VDD.n19 VDD.n84 2.75725
R192 VDD.n160 VDD.n83 9.8005
R193 VDD.n161 VDD.n20 2.75725
R194 VDD.n161 VDD.n81 9.8005
R195 VDD.n165 VDD.n81 9.8005
R196 VDD.n165 VDD.n39 2.75725
R197 VDD.n166 VDD.n46 9.8005
R198 VDD.n166 VDD.n79 9.8005
R199 VDD.n170 VDD.n21 2.75725
R200 VDD.n170 VDD.n78 9.8005
R201 VDD.n171 VDD.n22 2.75725
R202 VDD.n171 VDD.n76 9.8005
R203 VDD.n175 VDD.n43 2.75725
R204 VDD.n175 VDD.n74 9.8005
R205 VDD.n176 VDD.n23 2.75725
R206 VDD.n176 VDD.n71 9.8005
R207 VDD.n180 VDD.n42 2.75725
R208 VDD.n180 VDD.n24 9.8005
R209 VDD.n181 VDD.n24 9.8005
R210 VDD.n25 VDD.n68 2.75725
R211 VDD.n185 VDD.n68 9.8005
R212 VDD.n27 VDD.n26 2.75725
R213 VDD.n186 VDD.n26 9.8005
R214 VDD.n45 VDD.n66 2.75725
R215 VDD.n190 VDD.n66 9.8005
R216 VDD.n190 VDD.n65 9.8005
R217 VDD.n191 VDD.n28 2.75725
R218 VDD.n191 VDD.n63 9.8005
R219 VDD.n195 VDD.n31 2.75725
R220 VDD.n195 VDD.n29 9.8005
R221 VDD.n196 VDD.n29 9.8005
R222 VDD.n38 VDD.n59 2.75725
R223 VDD.n200 VDD.n59 9.8005
R224 VDD.n200 VDD.n58 9.8005
R225 VDD.n41 VDD.n58 2.75725
R226 VDD.n202 VDD.n201 9.8005
R227 VDD.n53 VDD.n52 9.8005
R228 VDD.n8 VDD.n49 4.93411
R229 VDD.n159 VDD.t34 7.34444
R230 VDD.n164 VDD.t44 7.34444
R231 VDD.n178 VDD.t14 7.34444
R232 VDD.t66 VDD.n60 7.34444
R233 VDD.n11 VDD.n57 4.93411
R234 VDD VDD.n209 6.3005
R235 VDD.n208 VDD.n207 6.3005
R236 VDD.n37 VDD 1.77287
R237 VDD.n114 VDD.n50 6.3005
R238 VDD.n37 VDD.n50 2.75725
R239 VDD.n116 VDD.n115 6.3005
R240 VDD VDD.n116 6.3005
R241 VDD.n113 VDD.n111 6.3005
R242 VDD.n12 VDD.n111 2.75725
R243 VDD.n118 VDD.n117 6.3005
R244 VDD.n12 VDD 1.77287
R245 VDD.n119 VDD.n109 6.3005
R246 VDD.n36 VDD.n109 2.75725
R247 VDD.n121 VDD.n120 6.3005
R248 VDD VDD.n36 1.77287
R249 VDD.n110 VDD.n108 6.3005
R250 VDD.n13 VDD.n108 2.75725
R251 VDD.n123 VDD.n122 6.3005
R252 VDD.n13 VDD 1.77287
R253 VDD.n124 VDD.n107 6.3005
R254 VDD.n35 VDD.n107 2.75725
R255 VDD.n126 VDD.n125 6.3005
R256 VDD.n0 VDD.n35 1.77287
R257 VDD.n14 VDD.n104 6.3005
R258 VDD.n0 VDD.n14 6.3005
R259 VDD.t56 VDD.n127 6.3005
R260 VDD.n127 VDD.n40 2.75725
R261 VDD.n128 VDD.n103 6.3005
R262 VDD.n40 VDD.n0 1.77287
R263 VDD.n130 VDD.n129 6.3005
R264 VDD.n0 VDD.n130 6.3005
R265 VDD.n102 VDD.n101 6.3005
R266 VDD.n0 VDD.n44 1.77287
R267 VDD.n132 VDD.n131 6.3005
R268 VDD.n131 VDD.n44 2.75725
R269 VDD.n133 VDD.n100 6.3005
R270 VDD.n100 VDD.n0 6.3005
R271 VDD.n135 VDD.n134 6.3005
R272 VDD.n0 VDD.n34 1.77287
R273 VDD.n98 VDD.n97 6.3005
R274 VDD.n34 VDD.n98 2.75725
R275 VDD.n137 VDD.n136 6.3005
R276 VDD.n136 VDD.n15 2.75725
R277 VDD.n138 VDD.n96 6.3005
R278 VDD.n15 VDD.n0 1.77287
R279 VDD.n140 VDD.n139 6.3005
R280 VDD.n17 VDD.n140 2.75725
R281 VDD.n16 VDD.n95 6.3005
R282 VDD.n0 VDD.n17 1.77287
R283 VDD.n142 VDD.n141 6.3005
R284 VDD.n141 VDD.n0 6.3005
R285 VDD.n143 VDD.n48 6.3005
R286 VDD.n0 VDD.n30 1.77287
R287 VDD.n145 VDD.n144 6.3005
R288 VDD.n30 VDD.n145 2.75725
R289 VDD.n93 VDD.n92 6.3005
R290 VDD.n0 VDD.n10 1.77287
R291 VDD.n147 VDD.n146 6.3005
R292 VDD.n146 VDD.n10 2.75725
R293 VDD.n148 VDD.n47 6.3005
R294 VDD.n0 VDD.n32 1.77287
R295 VDD.n150 VDD.n149 6.3005
R296 VDD.n32 VDD.n150 2.75725
R297 VDD.n91 VDD.n9 6.3005
R298 VDD.n1 VDD.n9 6.3005
R299 VDD.n152 VDD.n151 6.3005
R300 VDD.n151 VDD.n18 2.75725
R301 VDD.n153 VDD.n88 6.3005
R302 VDD.n18 VDD.n1 1.77287
R303 VDD.n155 VDD.n154 6.3005
R304 VDD.n1 VDD.n155 6.3005
R305 VDD.n89 VDD.n86 6.3005
R306 VDD.n1 VDD.n33 1.77287
R307 VDD.n157 VDD.n156 6.3005
R308 VDD.n156 VDD.n33 2.75725
R309 VDD.n158 VDD.n84 6.3005
R310 VDD.n19 VDD.n1 1.77287
R311 VDD.n160 VDD.n159 6.3005
R312 VDD.n19 VDD.n160 2.75725
R313 VDD.n85 VDD.n83 6.3005
R314 VDD.n20 VDD.n83 2.75725
R315 VDD.n162 VDD.n161 6.3005
R316 VDD.n20 VDD.n1 1.77287
R317 VDD.n163 VDD.n81 6.3005
R318 VDD.n81 VDD.n1 6.3005
R319 VDD.n165 VDD.n164 6.3005
R320 VDD.n1 VDD.n39 1.77287
R321 VDD.n82 VDD.n46 6.3005
R322 VDD.n39 VDD.n46 2.75725
R323 VDD.n167 VDD.n166 6.3005
R324 VDD.n166 VDD.n1 6.3005
R325 VDD.n168 VDD.n79 6.3005
R326 VDD.n79 VDD.n21 2.75725
R327 VDD.n170 VDD.n169 6.3005
R328 VDD.n1 VDD.n21 1.77287
R329 VDD.n78 VDD.n77 6.3005
R330 VDD.n22 VDD.n78 2.75725
R331 VDD.n172 VDD.n171 6.3005
R332 VDD.n22 VDD.n7 1.77287
R333 VDD.n173 VDD.n76 6.3005
R334 VDD.n43 VDD.n76 2.75725
R335 VDD.n175 VDD.n174 6.3005
R336 VDD.n7 VDD.n43 1.77287
R337 VDD.n74 VDD.n73 6.3005
R338 VDD.n23 VDD.n74 2.75725
R339 VDD.n177 VDD.n176 6.3005
R340 VDD.n23 VDD.n7 1.77287
R341 VDD.n178 VDD.n71 6.3005
R342 VDD.n42 VDD.n71 2.75725
R343 VDD.n180 VDD.n179 6.3005
R344 VDD.n7 VDD.n42 1.77287
R345 VDD.n72 VDD.n24 6.3005
R346 VDD.n7 VDD.n24 6.3005
R347 VDD.n182 VDD.n181 6.3005
R348 VDD.n181 VDD.n25 2.75725
R349 VDD.n183 VDD.n68 6.3005
R350 VDD.n25 VDD.n7 1.77287
R351 VDD.n185 VDD.n184 6.3005
R352 VDD.n27 VDD.n185 2.75725
R353 VDD.n69 VDD.n26 6.3005
R354 VDD.n7 VDD.n27 1.77287
R355 VDD.n187 VDD.n186 6.3005
R356 VDD.n186 VDD.n45 2.75725
R357 VDD.n188 VDD.n66 6.3005
R358 VDD.n45 VDD.n4 1.77287
R359 VDD.n190 VDD.n189 6.3005
R360 VDD.n4 VDD.n190 6.3005
R361 VDD.n65 VDD.n64 6.3005
R362 VDD.n28 VDD.n65 2.75725
R363 VDD.n192 VDD.n191 6.3005
R364 VDD.n28 VDD.n4 1.77287
R365 VDD.n193 VDD.n63 6.3005
R366 VDD.n31 VDD.n63 2.75725
R367 VDD.n195 VDD.n194 6.3005
R368 VDD.n4 VDD.n31 1.77287
R369 VDD.n29 VDD.n61 6.3005
R370 VDD.n4 VDD.n29 6.3005
R371 VDD.n197 VDD.n196 6.3005
R372 VDD.n196 VDD.n38 2.75725
R373 VDD.n198 VDD.n59 6.3005
R374 VDD.n38 VDD.n5 1.77287
R375 VDD.n200 VDD.n199 6.3005
R376 VDD.n5 VDD.n200 6.3005
R377 VDD.n60 VDD.n58 6.3005
R378 VDD.n5 VDD.n41 1.77287
R379 VDD.n201 VDD.n56 6.3005
R380 VDD.n201 VDD.n41 2.75725
R381 VDD.n203 VDD.n202 6.3005
R382 VDD.n202 VDD.n11 2.17736
R383 VDD.n204 VDD.n203 6.3005
R384 VDD.n5 VDD.n6 1.77287
R385 VDD.n11 VDD.n5 2.06282
R386 VDD.n8 VDD.n2 1.77287
R387 VDD.n2 VDD.n53 6.3005
R388 VDD.n206 VDD.n52 6.3005
R389 VDD.n206 VDD.n205 6.3005
R390 VDD.n55 VDD.n3 5.4873
R391 VDD.n4 VDD.n67 5.42746
R392 VDD.n7 VDD.n70 5.42746
R393 VDD.n7 VDD.n75 5.42746
R394 VDD.n1 VDD.n80 5.42746
R395 VDD.n1 VDD.n87 5.42746
R396 VDD.n0 VDD.n90 5.42746
R397 VDD.n0 VDD.n94 5.42746
R398 VDD.n0 VDD.n99 5.42746
R399 VDD.n4 VDD.t27 4.32793
R400 VDD VDD.t51 4.32793
R401 VDD VDD.t8 4.32793
R402 VDD.n5 VDD.t67 4.32597
R403 VDD.n0 VDD.t1 4.32597
R404 VDD VDD.t33 4.32597
R405 VDD.n5 VDD.n62 2.91159
R406 VDD.n0 VDD.n105 2.91159
R407 VDD.n0 VDD.n106 2.91159
R408 VDD VDD.n112 2.91159
R409 VDD.n204 VDD.n3 2.82549
R410 VDD.n205 VDD.n54 2.82549
R411 VDD.n6 VDD.n55 5.514
R412 VDD.n6 VDD.n57 5.514
R413 VDD.n53 VDD.n51 2.75725
R414 VDD.n8 VDD.n51 5.514
R415 VDD.n54 VDD.n52 2.73055
R416 VDD.n209 VDD.n49 2.17736
R417 VDD.n206 VDD.n49 2.06282
R418 VDD.n5 VDD.n3 2.03587
R419 VDD.n54 VDD.n2 2.03587
R420 VDD.n203 VDD.n55 1.77287
R421 VDD.n203 VDD.n57 1.77287
R422 VDD.n206 VDD.n51 1.77287
R423 VDD.n7 VDD.n1 1.5965
R424 VDD.n1 VDD.n0 1.4285
R425 VDD.n62 VDD.t29 1.41684
R426 VDD.n62 VDD.t65 1.41684
R427 VDD.n67 VDD.t23 1.41684
R428 VDD.n67 VDD.t25 1.41684
R429 VDD.n70 VDD.t15 1.41684
R430 VDD.n70 VDD.t21 1.41684
R431 VDD.n75 VDD.t6 1.41684
R432 VDD.n75 VDD.t12 1.41684
R433 VDD.n80 VDD.t45 1.41684
R434 VDD.n80 VDD.t49 1.41684
R435 VDD.n87 VDD.t43 1.41684
R436 VDD.n87 VDD.t47 1.41684
R437 VDD.n90 VDD.t17 1.41684
R438 VDD.n90 VDD.t19 1.41684
R439 VDD.n94 VDD.t61 1.41684
R440 VDD.n94 VDD.t63 1.41684
R441 VDD.n99 VDD.t69 1.41684
R442 VDD.n99 VDD.t71 1.41684
R443 VDD.n105 VDD.t57 1.41684
R444 VDD.n105 VDD.t3 1.41684
R445 VDD.n106 VDD.t10 1.41684
R446 VDD.n106 VDD.t55 1.41684
R447 VDD.n112 VDD.t53 1.41684
R448 VDD.n112 VDD.t31 1.41684
R449 VDD.n5 VDD.n4 1.1285
R450 VDD VDD.n2 1.1285
R451 VDD.n4 VDD.n7 1.0085
R452 VDD VDD.n0 1.0085
R453 VSS.n223 VSS.n222 1325.17
R454 VSS.n226 VSS.n225 513.399
R455 VSS.n127 VSS.n126 513.399
R456 VSS.n127 VSS.n125 513.399
R457 VSS.n131 VSS.n130 513.399
R458 VSS.n131 VSS.n121 513.399
R459 VSS.n134 VSS.n121 513.399
R460 VSS.n136 VSS.n135 513.399
R461 VSS.n136 VSS.n120 513.399
R462 VSS.n140 VSS.n139 513.399
R463 VSS.n140 VSS.n119 513.399
R464 VSS.n144 VSS.n143 513.399
R465 VSS.n144 VSS.n116 513.399
R466 VSS.n147 VSS.n116 513.399
R467 VSS.n148 VSS.n114 513.399
R468 VSS.n150 VSS.n114 513.399
R469 VSS.n152 VSS.n151 513.399
R470 VSS.n152 VSS.n112 513.399
R471 VSS.n155 VSS.n112 513.399
R472 VSS.n156 VSS.n110 513.399
R473 VSS.n159 VSS.n110 513.399
R474 VSS.n161 VSS.n160 513.399
R475 VSS.n161 VSS.n106 513.399
R476 VSS.n164 VSS.n106 513.399
R477 VSS.n166 VSS.n165 513.399
R478 VSS.n166 VSS.n105 513.399
R479 VSS.n170 VSS.n169 513.399
R480 VSS.n170 VSS.n102 513.399
R481 VSS.n173 VSS.n102 513.399
R482 VSS.n175 VSS.n174 513.399
R483 VSS.n175 VSS.n101 513.399
R484 VSS.n179 VSS.n178 513.399
R485 VSS.n180 VSS.n179 513.399
R486 VSS.n180 VSS.n98 513.399
R487 VSS.n184 VSS.n183 513.399
R488 VSS.n185 VSS.n184 513.399
R489 VSS.n189 VSS.n96 513.399
R490 VSS.n190 VSS.n189 513.399
R491 VSS.n191 VSS.n190 513.399
R492 VSS.n194 VSS.n94 513.399
R493 VSS.n195 VSS.n194 513.399
R494 VSS.n196 VSS.n92 513.399
R495 VSS.n200 VSS.n92 513.399
R496 VSS.n201 VSS.n200 513.399
R497 VSS.n202 VSS.n90 513.399
R498 VSS.n205 VSS.n90 513.399
R499 VSS.n206 VSS.n205 513.399
R500 VSS.n207 VSS.n86 513.399
R501 VSS.n210 VSS.n86 513.399
R502 VSS.n212 VSS.n211 513.399
R503 VSS.n212 VSS.n85 513.399
R504 VSS.n216 VSS.n215 513.399
R505 VSS.n217 VSS.n216 513.399
R506 VSS.n217 VSS.n82 513.399
R507 VSS.n207 VSS.t19 495.063
R508 VSS.n105 VSS.t22 490.481
R509 VSS.n165 VSS.t4 462.976
R510 VSS.n156 VSS.t34 458.392
R511 VSS.n135 VSS.t6 453.808
R512 VSS.t11 VSS.n94 421.721
R513 VSS.n101 VSS.t24 417.137
R514 VSS.t18 VSS.n150 412.553
R515 VSS.n119 VSS.t0 398.801
R516 VSS.n125 VSS.t16 380.466
R517 VSS.n183 VSS.t21 366.714
R518 VSS.t2 VSS.n195 362.13
R519 VSS.n148 VSS.t32 343.795
R520 VSS.n211 VSS.t14 343.795
R521 VSS.n185 VSS.t8 339.211
R522 VSS.n85 VSS.t30 325.459
R523 VSS.t10 VSS.n159 320.875
R524 VSS.n174 VSS.t20 293.372
R525 VSS.n126 VSS.t26 288.788
R526 VSS.t12 VSS.n201 288.788
R527 VSS.n139 VSS.t28 270.452
R528 VSS.n120 VSS.t28 242.948
R529 VSS.n226 VSS.t26 224.613
R530 VSS.n202 VSS.t12 224.613
R531 VSS.t20 VSS.n173 220.029
R532 VSS.n160 VSS.t10 192.525
R533 VSS.n215 VSS.t30 187.941
R534 VSS.t8 VSS.n96 174.19
R535 VSS.t32 VSS.n147 169.606
R536 VSS.t14 VSS.n210 169.606
R537 VSS.n196 VSS.t2 151.269
R538 VSS.n98 VSS.t21 146.685
R539 VSS.n130 VSS.t16 132.935
R540 VSS.n143 VSS.t0 114.599
R541 VSS.n151 VSS.t18 100.847
R542 VSS.n178 VSS.t24 96.2628
R543 VSS.n191 VSS.t11 91.6789
R544 VSS.t6 VSS.n134 59.5915
R545 VSS.t34 VSS.n155 55.0075
R546 VSS.t4 VSS.n164 50.4236
R547 VSS.n169 VSS.t22 22.9201
R548 VSS.t19 VSS.n206 18.3362
R549 VSS.n218 VSS.n48 2.66071
R550 VSS.n204 VSS.n89 10.8894
R551 VSS.n208 VSS.n47 2.66071
R552 VSS.n208 VSS.n88 10.8894
R553 VSS.n199 VSS.n74 10.8894
R554 VSS.n192 VSS.n95 10.8894
R555 VSS.n45 VSS.n44 2.66071
R556 VSS.n193 VSS.n44 10.8894
R557 VSS.n46 VSS.n69 2.66071
R558 VSS.n181 VSS.n41 10.8894
R559 VSS.n182 VSS.n41 10.8894
R560 VSS.n43 VSS.n42 2.66071
R561 VSS.n186 VSS.n42 10.8894
R562 VSS.n172 VSS.n66 10.8894
R563 VSS.n39 VSS.n100 2.66071
R564 VSS.n176 VSS.n100 10.8894
R565 VSS.n40 VSS.n65 2.66071
R566 VSS.n167 VSS.n104 10.8894
R567 VSS.n158 VSS.n70 10.8894
R568 VSS.n38 VSS.n109 2.66071
R569 VSS.n162 VSS.n109 10.8894
R570 VSS.n162 VSS.n108 10.8894
R571 VSS.n35 VSS.n113 2.66071
R572 VSS.n153 VSS.n113 10.8894
R573 VSS.n37 VSS.n36 2.66071
R574 VSS.n137 VSS.n79 10.8894
R575 VSS.n227 VSS.n81 10.8894
R576 VSS.n213 VSS.n71 10.8507
R577 VSS.n149 VSS.n80 10.8507
R578 VSS.n209 VSS.n50 2.6499
R579 VSS.n146 VSS.n61 10.7992
R580 VSS.n128 VSS.n52 2.63743
R581 VSS.n141 VSS.n55 2.63116
R582 VSS.n204 VSS.n31 2.61532
R583 VSS.n133 VSS.n59 10.49
R584 VSS.n154 VSS.n36 10.4771
R585 VSS.n58 VSS.n108 2.60894
R586 VSS.n218 VSS.n78 10.4126
R587 VSS.n33 VSS.n95 2.59768
R588 VSS.n199 VSS.n56 2.58958
R589 VSS.n63 VSS.n104 2.58307
R590 VSS.n60 VSS.n59 2.58307
R591 VSS.n62 VSS.n61 2.57652
R592 VSS.n181 VSS.n64 2.56994
R593 VSS.n177 VSS.n65 10.0519
R594 VSS.n142 VSS.n67 10.0003
R595 VSS.n34 VSS.n66 2.54328
R596 VSS.n129 VSS.n68 9.94879
R597 VSS.n197 VSS.n69 9.89725
R598 VSS.n187 VSS.n49 2.52805
R599 VSS.n214 VSS.n53 2.52293
R600 VSS.n167 VSS.n75 9.74264
R601 VSS.n157 VSS.n51 2.51436
R602 VSS.n54 VSS.n25 2.51264
R603 VSS.n203 VSS.n57 2.50919
R604 VSS.n138 VSS.n32 2.49182
R605 VSS.n209 VSS.n6 9.27761
R606 VSS.n146 VSS.n5 9.27761
R607 VSS.n128 VSS.n0 8.60291
R608 VSS.n141 VSS.n24 8.26556
R609 VSS.n14 VSS.n13 7.42219
R610 VSS.n30 VSS.n81 7.38939
R611 VSS.n219 VSS.n83 7.38939
R612 VSS.n133 VSS.n27 2.4182
R613 VSS.n154 VSS.n20 2.40308
R614 VSS.n163 VSS.n76 7.08484
R615 VSS.n12 VSS.n78 2.32493
R616 VSS.n188 VSS.n15 6.49448
R617 VSS.n198 VSS.n72 6.07279
R618 VSS.n2 VSS 6.0695
R619 VSS.n2 VSS 5.792
R620 VSS.n168 VSS.n19 5.73544
R621 VSS.n132 VSS.n28 5.73544
R622 VSS VSS.n223 5.41963
R623 VSS.n222 VSS.n4 5.41963
R624 VSS.n145 VSS.n22 5.39809
R625 VSS.n2 VSS 5.2235
R626 VSS.n227 VSS.n226 5.2005
R627 VSS.n1 VSS.n227 3.00607
R628 VSS.n225 VSS.n81 5.2005
R629 VSS.n81 VSS 5.2005
R630 VSS.n128 VSS.n127 5.2005
R631 VSS VSS.n52 1.28278
R632 VSS.n126 VSS.n0 5.2005
R633 VSS.n1 VSS 0.552811
R634 VSS.n125 VSS.n68 5.2005
R635 VSS.n52 VSS.n68 2.63743
R636 VSS.n132 VSS.n131 5.2005
R637 VSS.n60 VSS.n132 2.58307
R638 VSS.n130 VSS.n129 5.2005
R639 VSS.n129 VSS.n29 1.57624
R640 VSS.n59 VSS.n121 5.2005
R641 VSS VSS.n60 1.30997
R642 VSS.n135 VSS.n25 5.2005
R643 VSS VSS.n54 1.34518
R644 VSS.n134 VSS.n133 5.2005
R645 VSS.n27 VSS 1.0508
R646 VSS.n120 VSS.n79 5.2005
R647 VSS.n32 VSS.n79 2.49182
R648 VSS.n137 VSS.n136 5.2005
R649 VSS.n54 VSS.n137 2.51264
R650 VSS.n141 VSS.n140 5.2005
R651 VSS VSS.n55 1.28592
R652 VSS.n139 VSS.n138 5.2005
R653 VSS.n32 VSS 1.35559
R654 VSS.n119 VSS.n67 5.2005
R655 VSS.n55 VSS.n67 2.63116
R656 VSS.n145 VSS.n144 5.2005
R657 VSS.n62 VSS.n145 2.57652
R658 VSS.n143 VSS.n142 5.2005
R659 VSS.n142 VSS.n23 1.67338
R660 VSS.n61 VSS.n116 5.2005
R661 VSS VSS.n62 1.31324
R662 VSS.n5 VSS.n148 5.2005
R663 VSS.n147 VSS.n146 5.2005
R664 VSS.n146 VSS 5.2005
R665 VSS.n36 VSS.n112 5.2005
R666 VSS.n3 VSS.n37 1.27115
R667 VSS.n153 VSS.n152 5.2005
R668 VSS.n37 VSS.n153 2.66071
R669 VSS.n151 VSS.n113 5.2005
R670 VSS.n35 VSS 1.27115
R671 VSS.n150 VSS.n149 5.2005
R672 VSS.n149 VSS.n35 2.66071
R673 VSS.n80 VSS.n114 5.2005
R674 VSS.n157 VSS.n156 5.2005
R675 VSS.n3 VSS.n51 1.34432
R676 VSS.n155 VSS.n154 5.2005
R677 VSS.n20 VSS.n3 1.0565
R678 VSS.n108 VSS.n106 5.2005
R679 VSS.n3 VSS.n58 1.29703
R680 VSS.n162 VSS.n161 5.2005
R681 VSS.n3 VSS.n162 5.2005
R682 VSS.n160 VSS.n109 5.2005
R683 VSS.n38 VSS.n3 1.27115
R684 VSS.n159 VSS.n158 5.2005
R685 VSS.n158 VSS.n38 2.66071
R686 VSS.n70 VSS.n110 5.2005
R687 VSS.n51 VSS.n70 2.51436
R688 VSS.n165 VSS.n75 5.2005
R689 VSS.n3 VSS.n77 1.53021
R690 VSS.n164 VSS.n163 5.2005
R691 VSS.n163 VSS.n58 2.60894
R692 VSS.n105 VSS.n104 5.2005
R693 VSS.n3 VSS.n63 1.30997
R694 VSS.n167 VSS.n166 5.2005
R695 VSS.n3 VSS.n167 5.2005
R696 VSS.n171 VSS.n170 5.2005
R697 VSS.n34 VSS.n171 2.54328
R698 VSS.n169 VSS.n168 5.2005
R699 VSS.n168 VSS.n63 2.58307
R700 VSS.n101 VSS.n65 5.2005
R701 VSS.n3 VSS.n40 1.27115
R702 VSS.n176 VSS.n175 5.2005
R703 VSS.n40 VSS.n176 2.66071
R704 VSS.n174 VSS.n100 5.2005
R705 VSS.n39 VSS.n3 1.27115
R706 VSS.n173 VSS.n172 5.2005
R707 VSS.n172 VSS.n39 2.66071
R708 VSS.n66 VSS.n102 5.2005
R709 VSS.n3 VSS.n34 1.32986
R710 VSS.n179 VSS.n16 5.2005
R711 VSS.n64 VSS.n16 2.56994
R712 VSS.n178 VSS.n177 5.2005
R713 VSS.n177 VSS.n18 1.76546
R714 VSS.n186 VSS.n185 5.2005
R715 VSS.n186 VSS.n49 2.52805
R716 VSS.n184 VSS.n42 5.2005
R717 VSS.n2 VSS.n43 1.27115
R718 VSS.n183 VSS.n182 5.2005
R719 VSS.n182 VSS.n43 2.66071
R720 VSS.n98 VSS.n41 5.2005
R721 VSS.n2 VSS.n41 5.2005
R722 VSS.n181 VSS.n180 5.2005
R723 VSS.n2 VSS.n64 1.31653
R724 VSS.n189 VSS.n188 5.2005
R725 VSS.n188 VSS.n33 2.59768
R726 VSS.n187 VSS.n96 5.2005
R727 VSS.n2 VSS.n49 1.33747
R728 VSS.n195 VSS.n69 5.2005
R729 VSS.n2 VSS.n46 1.27115
R730 VSS.n194 VSS.n193 5.2005
R731 VSS.n193 VSS.n46 2.66071
R732 VSS.n44 VSS.n94 5.2005
R733 VSS.n2 VSS.n45 1.27115
R734 VSS.n192 VSS.n191 5.2005
R735 VSS.n45 VSS.n192 2.66071
R736 VSS.n190 VSS.n95 5.2005
R737 VSS.n33 VSS.n2 1.30266
R738 VSS.n72 VSS.n92 5.2005
R739 VSS.n56 VSS.n72 2.58958
R740 VSS.n197 VSS.n196 5.2005
R741 VSS.n73 VSS.n2 1.39819
R742 VSS.n201 VSS.n74 5.2005
R743 VSS.n57 VSS.n74 2.50919
R744 VSS.n200 VSS.n199 5.2005
R745 VSS.n56 VSS.n2 1.30671
R746 VSS.n13 VSS.n90 5.2005
R747 VSS.n31 VSS.n13 2.61532
R748 VSS.n203 VSS.n202 5.2005
R749 VSS.n57 VSS.n2 1.3469
R750 VSS.n88 VSS.n86 5.2005
R751 VSS.n50 VSS.n88 2.6499
R752 VSS.n208 VSS.n207 5.2005
R753 VSS.n2 VSS.n47 1.27115
R754 VSS.n206 VSS.n89 5.2005
R755 VSS.n89 VSS.n47 2.66071
R756 VSS.n205 VSS.n204 5.2005
R757 VSS.n31 VSS.n2 1.29384
R758 VSS.n211 VSS.n6 5.2005
R759 VSS.n210 VSS.n209 5.2005
R760 VSS.n50 VSS.n2 1.27655
R761 VSS.n85 VSS.n71 5.2005
R762 VSS.n53 VSS.n71 2.52293
R763 VSS.n213 VSS.n212 5.2005
R764 VSS.n216 VSS.n78 5.2005
R765 VSS.n2 VSS.n12 1.08598
R766 VSS.n215 VSS.n214 5.2005
R767 VSS.n53 VSS.n2 1.34003
R768 VSS.n83 VSS.n82 5.2005
R769 VSS.n48 VSS.n83 2.66071
R770 VSS.n218 VSS.n217 5.2005
R771 VSS.n2 VSS.n48 1.27115
R772 VSS.n10 VSS.n4 1.27115
R773 VSS.n220 VSS.n10 5.32092
R774 VSS.n219 VSS.n4 5.2005
R775 VSS VSS.n30 5.2005
R776 VSS VSS.n9 1.27115
R777 VSS.n17 VSS.n16 5.06074
R778 VSS.n2 VSS 4.90325
R779 VSS.n11 VSS.n84 4.5995
R780 VSS.n6 VSS.n87 4.5995
R781 VSS.n14 VSS.n91 4.5995
R782 VSS.n198 VSS.t3 4.5995
R783 VSS.n198 VSS.n93 4.5995
R784 VSS.n15 VSS.n97 4.5995
R785 VSS.n17 VSS.n99 4.5995
R786 VSS.n19 VSS.n103 4.5995
R787 VSS.n76 VSS.t5 4.5995
R788 VSS.n76 VSS.n107 4.5995
R789 VSS.n21 VSS.n111 4.5995
R790 VSS.n5 VSS.n115 4.5995
R791 VSS.n22 VSS.n117 4.5995
R792 VSS.n24 VSS.n118 4.5995
R793 VSS.n26 VSS.n122 4.5995
R794 VSS.n28 VSS.n123 4.5995
R795 VSS.n0 VSS.n124 4.5995
R796 VSS.n11 VSS.t31 4.4105
R797 VSS.n6 VSS.t15 4.4105
R798 VSS.n14 VSS.t13 4.4105
R799 VSS.n15 VSS.t9 4.4105
R800 VSS.n17 VSS.t25 4.4105
R801 VSS.n19 VSS.t23 4.4105
R802 VSS.n21 VSS.t35 4.4105
R803 VSS.n5 VSS.t33 4.4105
R804 VSS.n22 VSS.t1 4.4105
R805 VSS.n24 VSS.t29 4.4105
R806 VSS.n26 VSS.t7 4.4105
R807 VSS.n28 VSS.t17 4.4105
R808 VSS.n0 VSS.t27 4.4105
R809 VSS.n18 VSS.n17 1.13399
R810 VSS.n2 VSS 4.30775
R811 VSS.n23 VSS.n22 1.07486
R812 VSS.n2 VSS 4.00219
R813 VSS.n2 VSS 3.81406
R814 VSS.n2 VSS 3.7325
R815 VSS.n171 VSS.n19 3.71134
R816 VSS.n29 VSS.n28 1.01248
R817 VSS.n2 VSS 3.42864
R818 VSS.n19 VSS.n3 3.3395
R819 VSS.n3 VSS.n18 1.3444
R820 VSS.n23 VSS 1.3804
R821 VSS.n29 VSS 1.41839
R822 VSS.n73 VSS.n197 1.49733
R823 VSS.n2 VSS 3.20897
R824 VSS.n3 VSS 3.1565
R825 VSS.n27 VSS.n26 1.46527
R826 VSS.n24 VSS 3.1505
R827 VSS.n5 VSS 1.21585
R828 VSS.n21 VSS.n20 1.45611
R829 VSS.n77 VSS.n76 0.695449
R830 VSS.n2 VSS.n15 3.1505
R831 VSS.n73 VSS.n198 0.907428
R832 VSS.n2 VSS.n14 3.1505
R833 VSS.n7 VSS.n6 1.21585
R834 VSS.n12 VSS.n11 1.40876
R835 VSS.n187 VSS.n15 3.14131
R836 VSS.n214 VSS.n11 2.8883
R837 VSS.n3 VSS 2.83625
R838 VSS.n2 VSS 2.80779
R839 VSS.n223 VSS.n8 2.66071
R840 VSS.n222 VSS.n221 2.66071
R841 VSS.n224 VSS.n30 2.66071
R842 VSS.n224 VSS.n9 5.32092
R843 VSS.n9 VSS.n8 5.32092
R844 VSS.n220 VSS.n219 2.66071
R845 VSS.n221 VSS.n10 5.32092
R846 VSS.n213 VSS.n7 3.00215
R847 VSS VSS.n80 3.00215
R848 VSS.n157 VSS.n21 2.46661
R849 VSS.n3 VSS 2.41779
R850 VSS.n26 VSS.n25 2.38227
R851 VSS.n77 VSS.n75 1.14739
R852 VSS.n3 VSS 2.24525
R853 VSS.n14 VSS.n203 2.2136
R854 VSS.n3 VSS 2.02728
R855 VSS.n1 VSS.n0 1.92998
R856 VSS.n3 VSS 1.80762
R857 VSS.n3 VSS 1.63582
R858 VSS.n3 VSS 1.40948
R859 VSS.n2 VSS.n7 1.39801
R860 VSS.n138 VSS.n24 1.37022
R861 VSS.n221 VSS.n82 1.27115
R862 VSS.n220 VSS.n82 1.27115
R863 VSS.n225 VSS.n224 1.27115
R864 VSS.n225 VSS.n8 1.27115
R865 VSS.n3 VSS.n2 1.23726
R866 VSS.n4 VSS.n2 1.02426
R867 a_6694_987.t0 a_6694_987.n1 4.91293
R868 a_6694_987.n1 a_6694_987.t2 4.89923
R869 a_6694_987.n1 a_6694_987.n0 2.6005
R870 a_6694_987.n0 a_6694_987.t3 1.41684
R871 a_6694_987.n0 a_6694_987.t1 1.41684
R872 a_5474_987.t0 a_5474_987.n2 4.89923
R873 a_5474_987.n0 a_5474_987.t1 4.77206
R874 a_5474_987.n0 a_5474_987.t3 4.14793
R875 a_5474_987.n0 a_5474_987.t2 4.14597
R876 a_5474_987.n2 a_5474_987.n1 2.6005
R877 a_5474_987.n1 a_5474_987.t5 1.41684
R878 a_5474_987.n1 a_5474_987.t4 1.41684
R879 a_5474_987.n2 a_5474_987.n0 1.02376
R880 a_4706_987.n1 a_4706_987.t2 4.91293
R881 a_4706_987.t0 a_4706_987.n1 4.89923
R882 a_4706_987.n1 a_4706_987.n0 2.6005
R883 a_4706_987.n0 a_4706_987.t1 1.41684
R884 a_4706_987.n0 a_4706_987.t3 1.41684
R885 a_3938_987.n0 a_3938_987.t2 4.91293
R886 a_3938_987.n0 a_3938_987.t1 4.89923
R887 a_3938_987.n1 a_3938_987.n0 2.6005
R888 a_3938_987.t0 a_3938_987.n1 1.41684
R889 a_3938_987.n1 a_3938_987.t3 1.41684
R890 a_2717_987.n1 a_2717_987.t3 4.89923
R891 a_2717_987.n0 a_2717_987.t4 4.77206
R892 a_2717_987.n0 a_2717_987.t1 4.14793
R893 a_2717_987.n0 a_2717_987.t5 4.14597
R894 a_2717_987.n2 a_2717_987.n1 2.6005
R895 a_2717_987.t0 a_2717_987.n2 1.41684
R896 a_2717_987.n2 a_2717_987.t2 1.41684
R897 a_2717_987.n1 a_2717_987.n0 1.02572
R898 a_1948_987.n0 a_1948_987.t2 4.91293
R899 a_1948_987.n0 a_1948_987.t1 4.89923
R900 a_1948_987.n1 a_1948_987.n0 2.6005
R901 a_1948_987.t0 a_1948_987.n1 1.41684
R902 a_1948_987.n1 a_1948_987.t3 1.41684
R903 in2.n4 in2.t7 37.891
R904 in2.n4 in2.t8 19.2934
R905 in2.n3 in2.t2 11.4691
R906 in2.n3 in2.n1 10.7239
R907 in2.n0 in2.n6 10.32
R908 in2.n6 in2.n4 8.00323
R909 in2 in2.n3 7.25257
R910 in2.n6 in2.n5 5.2005
R911 in2.t2 in2.n2 3.1489
R912 in2 in2.t6 6.99436
R913 in2.n0 in2.t5 6.98303
R914 in2.n5 in2.t0 1.41684
R915 in2.n5 in2.t1 1.41684
R916 in2.n1 in2.t3 1.41684
R917 in2.n1 in2.t4 1.41684
R918 in2 in2.n0 1.28661
R919 R.n2 R.t5 40.1505
R920 R.n4 R.t7 40.1505
R921 R.n7 R.n0 3.4241
R922 R.n2 R.t6 19.2934
R923 R.n4 R.t8 19.2934
R924 R.n3 R.n2 15.8889
R925 R.n5 R.n4 15.8274
R926 R R.n0 11.9997
R927 R.n6 R.n3 9.97466
R928 R.n3 R.t3 18.3359
R929 R R.n1 8.08589
R930 R.n6 R.n5 4.5005
R931 R.t0 R.n0 0.654944
R932 R.n1 R.t1 1.41684
R933 R.n1 R.t2 1.41684
R934 R.t4 R.n5 15.6121
R935 R R.n6 8.26172
R936 in1.n3 in1.t7 40.1505
R937 in1.n5 in1.n3 28.1582
R938 in1.n3 in1.t8 19.2934
R939 in1.n2 in1.t3 11.3048
R940 in1.n2 in1.n1 10.6945
R941 in1.n0 in1.n5 10.4576
R942 in1 in1.n2 7.34541
R943 in1.n5 in1.n4 5.2005
R944 in1 in1.t6 9.58619
R945 in1.n0 in1.t0 6.98303
R946 in1.n1 in1.t1 1.41684
R947 in1.n1 in1.t2 1.41684
R948 in1.n4 in1.t4 1.41684
R949 in1.n4 in1.t5 1.41684
R950 in1 in1.n0 1.32552
C0 R in2 0.37322f
C1 CLKb a_921_203r# 0.10805f
C2 in1 VDD 0.47561f
C3 QN out2 0.59751f
C4 CLKN SN 0.43801f
C5 in1 a_2824_203r# 0.26574f
C6 VDD CLK 0.61043f
C7 QN Q 0.51513f
C8 R D 0.22458f
C9 in1 CLKN 0.77711f
C10 CLKb out1 0.57291f
C11 CLKN CLK 0.47342f
C12 a_4807_203r# out1 0.13364f
C13 in1 a_2065_203r# 0.13049f
C14 out1 a_4039_203r# 0.36343f
C15 VDD SNb 1.06377f
C16 in1 D 0.10739f
C17 CLKb VDD 1.30194f
C18 CLKN SNb 2.08072f
C19 in1 R 0.41541f
C20 a_6795_203r# out2 0.39626f
C21 out2 VDD 0.87993f
C22 RN SNb 0.2566f
C23 CLKb CLKN 2.0992f
C24 Q VDD 0.56614f
C25 in2 SNb 0.38611f
C26 QN VDD 0.82511f
C27 out2 CLKN 0.92761f
C28 CLKb RN 0.16995f
C29 VDD a_921_203r# 0.67957f
C30 CLKb in2 1.29557f
C31 CLKN a_921_203r# 0.26086f
C32 out2 in2 1.76488f
C33 R SNb 5.08039f
C34 out1 VDD 0.66706f
C35 CLKb D 0.32353f
C36 RN a_921_203r# 0.1437f
C37 CLKb R 2.06517f
C38 out1 CLKN 0.98619f
C39 out2 R 0.52544f
C40 a_5574_203r# in2 0.2574f
C41 in1 SNb 0.4011f
C42 CLKb SN 0.49584f
C43 CLKN VDD 1.73157f
C44 CLKb in1 1.51544f
C45 R out1 0.53117f
C46 RN VDD 0.41096f
C47 a_6795_203r# in2 0.15859f
C48 VDD in2 0.50929f
C49 CLKN RN 0.34923f
C50 SN a_921_203r# 0.3929f
C51 CLKN in2 0.88826f
C52 D VDD 0.31795f
C53 CLKb SNb 4.59003f
C54 R VDD 1.26294f
C55 D CLKN 0.43385f
C56 in1 out1 1.82977f
C57 D a_2065_203r# 0.1386f
C58 R CLKN 3.90695f
C59 R RN 0.23272f
C60 a_921_203r# SNb 0.44284f
C61 SN VDD 0.56591f
C62 Q VSS 0.90822f
C63 QN VSS 1.28989f
C64 D VSS 1.11002f
C65 RN VSS 0.77227f
C66 SN VSS 1.04268f
C67 CLK VSS 1.05707f
C68 VDD VSS 22.33033f
C69 a_6795_203r# VSS 0.10892f
C70 a_5574_203r# VSS 0.11177f
C71 a_4807_203r# VSS 0.11034f
C72 a_4039_203r# VSS 0.10697f
C73 a_2824_203r# VSS 0.11018f
C74 a_2065_203r# VSS 0.11421f
C75 out2 VSS 1.17858f
C76 in2 VSS 2.03106f
C77 out1 VSS 1.19114f
C78 R VSS 2.45032f
C79 SNb VSS 1.13758f
C80 in1 VSS 2.15787f
C81 CLKb VSS 1.36664f
C82 a_921_203r# VSS 0.49088f
C83 CLKN VSS 1.62214f
C84 in1.t0 VSS 0.49796f
C85 in1.n0 VSS 0.6007f
C86 in1.n1 VSS 0.25173f
C87 in1.t3 VSS 0.42743f
C88 in1.n2 VSS 0.98493f
C89 in1.t8 VSS 0.10855f
C90 in1.t7 VSS 0.1731f
C91 in1.n3 VSS 0.24841f
C92 in1.n4 VSS 0.16293f
C93 in1.n5 VSS 0.67736f
C94 in1.t6 VSS 0.7047f
C95 R.n0 VSS 0.45202f
C96 R.t2 VSS 0.13805f
C97 R.t1 VSS 0.13805f
C98 R.n1 VSS 0.63327f
C99 R.t6 VSS 0.18396f
C100 R.t5 VSS 0.29335f
C101 R.n2 VSS 0.37318f
C102 R.t3 VSS 1.39749f
C103 R.n3 VSS 2.13186f
C104 R.t8 VSS 0.18396f
C105 R.t7 VSS 0.29335f
C106 R.n4 VSS 0.3574f
C107 R.t4 VSS 1.79056f
C108 R.n5 VSS 1.03523f
C109 R.n6 VSS 3.25505f
C110 R.n7 VSS 0.56387f
C111 in2.t5 VSS 0.49426f
C112 in2.n0 VSS 0.54217f
C113 in2.t2 VSS 0.29056f
C114 in2.n1 VSS 0.27091f
C115 in2.n2 VSS 0.13728f
C116 in2.n3 VSS 0.9799f
C117 in2.t8 VSS 0.10775f
C118 in2.t7 VSS 0.1682f
C119 in2.n4 VSS 0.27537f
C120 in2.n5 VSS 0.16172f
C121 in2.n6 VSS 0.82402f
C122 in2.t6 VSS 0.81958f
C123 a_1948_987.t1 VSS 0.26692f
C124 a_1948_987.t2 VSS 0.26798f
C125 a_1948_987.n0 VSS 0.75727f
C126 a_1948_987.n1 VSS 0.16984f
C127 a_2717_987.n0 VSS 0.8222f
C128 a_2717_987.t3 VSS 0.25182f
C129 a_2717_987.t1 VSS 0.20848f
C130 a_2717_987.t5 VSS 0.20839f
C131 a_2717_987.t4 VSS 0.24275f
C132 a_2717_987.n1 VSS 0.474f
C133 a_2717_987.n2 VSS 0.16024f
C134 a_3938_987.t1 VSS 0.27498f
C135 a_3938_987.t2 VSS 0.27608f
C136 a_3938_987.n0 VSS 0.78014f
C137 a_3938_987.n1 VSS 0.17497f
C138 a_4706_987.t2 VSS 0.27763f
C139 a_4706_987.n0 VSS 0.17595f
C140 a_4706_987.n1 VSS 0.78452f
C141 a_4706_987.t0 VSS 0.27652f
C142 a_5474_987.n0 VSS 0.81143f
C143 a_5474_987.t3 VSS 0.20589f
C144 a_5474_987.t2 VSS 0.2058f
C145 a_5474_987.t1 VSS 0.23973f
C146 a_5474_987.n1 VSS 0.15825f
C147 a_5474_987.n2 VSS 0.46811f
C148 a_5474_987.t0 VSS 0.24869f
C149 a_6694_987.t2 VSS 0.27692f
C150 a_6694_987.n0 VSS 0.17621f
C151 a_6694_987.n1 VSS 0.78565f
C152 a_6694_987.t0 VSS 0.27803f
C153 VDD.n0 VSS 0.64457f
C154 VDD.n1 VSS 0.41383f
C155 VDD.n4 VSS 0.23752f
C156 VDD.n5 VSS 0.2305f
C157 VDD.n7 VSS 0.34164f
C158 VDD.n56 VSS 0.16384f
C159 VDD.n61 VSS 0.10971f
C160 VDD.n64 VSS 0.10971f
C161 VDD.n69 VSS 0.14774f
C162 VDD.n72 VSS 0.11703f
C163 VDD.n73 VSS 0.13604f
C164 VDD.n77 VSS 0.13604f
C165 VDD.n82 VSS 0.11703f
C166 VDD.n85 VSS 0.11703f
C167 VDD.n92 VSS 0.16384f
C168 VDD.n95 VSS 0.16384f
C169 VDD.n104 VSS 0.11703f
C170 VDD.n110 VSS 0.14043f
C171 VDD.n113 VSS 0.11703f
C172 VDD.n115 VSS 0.10532f
C173 VDD.n118 VSS 0.10532f
C174 VDD.n120 VSS 0.15213f
C175 VDD.n123 VSS 0.10532f
C176 VDD.n125 VSS 0.11703f
C177 VDD.t56 VSS 0.16384f
C178 VDD.n128 VSS 0.11703f
C179 VDD.n129 VSS 0.11703f
C180 VDD.n132 VSS 0.16384f
C181 VDD.n133 VSS 0.11703f
C182 VDD.n134 VSS 0.11703f
C183 VDD.n137 VSS 0.10532f
C184 VDD.n138 VSS 0.11703f
C185 VDD.n139 VSS 0.10532f
C186 VDD.n142 VSS 0.10605f
C187 VDD.n143 VSS 0.11702f
C188 VDD.n144 VSS 0.10459f
C189 VDD.n147 VSS 0.10971f
C190 VDD.n148 VSS 0.11703f
C191 VDD.n149 VSS 0.10093f
C192 VDD.n152 VSS 0.11703f
C193 VDD.n153 VSS 0.11264f
C194 VDD.n154 VSS 0.16384f
C195 VDD.n157 VSS 0.11703f
C196 VDD.n158 VSS 0.11264f
C197 VDD.n162 VSS 0.12434f
C198 VDD.n163 VSS 0.16384f
C199 VDD.n167 VSS 0.11703f
C200 VDD.n169 VSS 0.10971f
C201 VDD.n172 VSS 0.15652f
C202 VDD.n174 VSS 0.10971f
C203 VDD.n177 VSS 0.15945f
C204 VDD.n179 VSS 0.11264f
C205 VDD.n183 VSS 0.10093f
C206 VDD.n184 VSS 0.14482f
C207 VDD.n188 VSS 0.10093f
C208 VDD.n189 VSS 0.11703f
C209 VDD.n193 VSS 0.15652f
C210 VDD.n194 VSS 0.13604f
C211 VDD.n198 VSS 0.11703f
C212 VDD.n199 VSS 0.11703f
C213 VDD.n203 VSS 0.30719f
C214 VDD.n204 VSS 0.33742f
C215 VDD.n205 VSS 0.33742f
C216 VDD.n206 VSS 0.21357f
C217 VDD.n207 VSS 0.15213f
C218 CLK.t0 VSS 0.41403f
C219 CLK.n0 VSS 0.10805f
C220 SN.t0 VSS 0.8508f
C221 SN.t1 VSS 0.13449f
C222 SN.n0 VSS 0.20461f
C223 RN.n0 VSS 0.34541f
C224 RN.n4 VSS 0.1104f
C225 RN.n6 VSS 0.22558f
C226 RN.t1 VSS 0.14174f
C227 RN.n7 VSS 0.24286f
C228 D.t1 VSS 0.12994f
C229 D.t2 VSS 0.10866f
C230 D.n0 VSS 0.30258f
C231 D.t0 VSS 0.68448f
C232 QN.t2 VSS 0.14743f
C233 QN.n1 VSS 0.16833f
C234 QN.t3 VSS 0.44108f
C235 QN.n2 VSS 0.15593f
C236 Q.t2 VSS 0.17267f
C237 Q.n0 VSS 0.10629f
C238 Q.n1 VSS 0.18317f
.ends
