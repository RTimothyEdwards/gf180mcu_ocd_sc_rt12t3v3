* NGSPICE file created from gf180mcu_ocd_sc_rt12t3v3__nand2_1.ext - technology: gf180mcuD

.subckt gf180mcu_ocd_sc_rt12t3v3__nand2_1 A B Y VDD VSS
X0 Y.t0 A.t0 a_193_203r# VSS.t0 nfet_03v3 ad=0.3087p pd=2.01u as=0.52065p ps=3.23u w=1.02u l=0.28u
X1 VDD.t7 B.t1 Y.t4 VDD.t6 pfet_03v3 ad=0.3341p pd=1.805u as=0.3341p ps=1.805u w=1.285u l=0.28u
X2 Y.t2 A.t2 VDD.t1 VDD.t0 pfet_03v3 ad=0.3341p pd=1.805u as=0.3341p ps=1.805u w=1.285u l=0.28u
X3 Y.t3 B.t2 VDD.t5 VDD.t4 pfet_03v3 ad=0.3341p pd=1.805u as=0.5654p ps=3.45u w=1.285u l=0.28u
X4 VDD.t3 A.t1 Y.t1 VDD.t2 pfet_03v3 ad=0.5654p pd=3.45u as=0.3341p ps=1.805u w=1.285u l=0.28u
X5 a_193_203r# B.t0 VSS.t2 VSS.t1 nfet_03v3 ad=0.3087p pd=2.01u as=5.19535p ps=29.85u w=1.02u l=0.28u
R0 Y Y.t0 6.60438
R1 Y.n2 Y.n1 3.3518
R2 Y.t0 Y.n3 3.1489
R3 Y.n2 Y.n0 2.72963
R4 Y Y.n2 1.50213
R5 Y.n1 Y.t3 1.41684
R6 Y.n1 Y.t4 1.41684
R7 Y.n0 Y.t2 1.41684
R8 Y.n0 Y.t1 1.41684
R9 A.n0 A.t1 40.1505
R10 A.n0 A.t2 19.2934
R11 A A.n0 9.82848
R12 A A.t0 8.43391
R13 B.n0 B.t1 40.1505
R14 B.n0 B.t2 19.2934
R15 B B.n0 10.0207
R16 B B.t0 6.85756
R17 VDD.n34 VDD.n33 137.088
R18 VDD.n24 VDD.n22 137.088
R19 VDD.n26 VDD.n21 137.088
R20 VDD.n30 VDD.n16 137.088
R21 VDD.n32 VDD.n31 122.707
R22 VDD.n34 VDD.t4 117.504
R23 VDD.t2 VDD.n16 117.504
R24 VDD.n25 VDD.t6 97.9197
R25 VDD.t0 VDD.n25 97.9197
R26 VDD.t6 VDD.n24 39.1682
R27 VDD.n26 VDD.t0 39.1682
R28 VDD.n22 VDD.t4 19.5843
R29 VDD.n21 VDD.t2 19.5843
R30 VDD.n36 VDD.n35 9.8005
R31 VDD.n35 VDD.n6 2.75725
R32 VDD.n23 VDD.n8 9.8005
R33 VDD.n4 VDD.n20 2.75725
R34 VDD.n27 VDD.n20 9.8005
R35 VDD.n27 VDD.n18 9.8005
R36 VDD.n5 VDD.n18 2.75725
R37 VDD.n29 VDD.n28 9.8005
R38 VDD.n13 VDD.n10 9.8005
R39 VDD.n12 VDD.n11 9.8005
R40 VDD.n3 VDD.n17 4.93411
R41 VDD VDD.n36 6.3005
R42 VDD.n35 VDD.n34 6.3005
R43 VDD.n6 VDD 1.77287
R44 VDD.n22 VDD.n8 6.3005
R45 VDD.n6 VDD.n8 2.75725
R46 VDD.n24 VDD.n23 6.3005
R47 VDD.n23 VDD.n4 2.75725
R48 VDD.n25 VDD.n20 6.3005
R49 VDD.n4 VDD.n1 1.77287
R50 VDD.n27 VDD.n26 6.3005
R51 VDD.n1 VDD.n27 6.3005
R52 VDD.n21 VDD.n18 6.3005
R53 VDD.n1 VDD.n5 1.77287
R54 VDD.n28 VDD.n16 6.3005
R55 VDD.n28 VDD.n5 2.75725
R56 VDD.n30 VDD.n29 6.3005
R57 VDD.n29 VDD.n3 2.17736
R58 VDD.n31 VDD.n30 6.3005
R59 VDD.n1 VDD.n2 1.77287
R60 VDD.n3 VDD.n1 2.06282
R61 VDD.n11 VDD 6.3005
R62 VDD VDD.n12 6.3005
R63 VDD VDD.n13 6.3005
R64 VDD.n33 VDD.n10 6.3005
R65 VDD.n33 VDD.n32 6.3005
R66 VDD.n15 VDD.n0 5.4873
R67 VDD.n1 VDD.n19 5.42159
R68 VDD.n1 VDD.t3 4.32793
R69 VDD VDD.t5 4.32793
R70 VDD.n31 VDD.n0 2.82549
R71 VDD.n32 VDD.n14 2.82549
R72 VDD.n2 VDD.n15 5.514
R73 VDD.n2 VDD.n17 5.514
R74 VDD.n13 VDD.n9 2.75725
R75 VDD.n12 VDD.n9 2.75725
R76 VDD.n14 VDD.n10 2.73055
R77 VDD.n11 VDD.n7 2.17736
R78 VDD.n36 VDD.n7 2.17736
R79 VDD.n33 VDD.n7 2.06282
R80 VDD.n1 VDD.n0 2.03587
R81 VDD.n14 VDD 2.03587
R82 VDD.n30 VDD.n15 1.77287
R83 VDD.n30 VDD.n17 1.77287
R84 VDD.n33 VDD.n9 1.77287
R85 VDD.n1 VDD 1.7525
R86 VDD.n19 VDD.t7 1.41684
R87 VDD.n19 VDD.t1 1.41684
R88 VSS.n31 VSS.n30 513.399
R89 VSS.n17 VSS.n16 513.399
R90 VSS.n17 VSS.n14 513.399
R91 VSS.n20 VSS.n14 513.399
R92 VSS.n22 VSS.n21 513.399
R93 VSS.n22 VSS.n12 513.399
R94 VSS.n21 VSS.t0 467.56
R95 VSS.n31 VSS.t1 316.291
R96 VSS.n16 VSS.t1 197.109
R97 VSS.n28 VSS.n27 149.174
R98 VSS.t0 VSS.n20 45.8397
R99 VSS.n19 VSS.n6 10.8894
R100 VSS.n8 VSS.n13 2.66071
R101 VSS.n23 VSS.n13 10.8894
R102 VSS.n10 VSS.n9 2.66071
R103 VSS.n32 VSS.n11 10.8894
R104 VSS.n18 VSS.n6 10.4384
R105 VSS.n32 VSS.n4 9.76841
R106 VSS.n7 VSS.n11 7.38939
R107 VSS.n24 VSS.n9 7.38939
R108 VSS.n18 VSS.n3 2.35671
R109 VSS VSS.n28 5.41963
R110 VSS.n27 VSS 5.41963
R111 VSS.n32 VSS.n31 5.2005
R112 VSS VSS.n32 5.2005
R113 VSS.n30 VSS.n11 5.2005
R114 VSS.n11 VSS 5.2005
R115 VSS.n18 VSS.n17 5.2005
R116 VSS.n16 VSS.n4 5.2005
R117 VSS.n4 VSS 5.2005
R118 VSS.n9 VSS.n12 5.2005
R119 VSS VSS.n10 1.27115
R120 VSS.n23 VSS.n22 5.2005
R121 VSS.n10 VSS.n23 2.66071
R122 VSS.n21 VSS.n13 5.2005
R123 VSS.n8 VSS 1.27115
R124 VSS.n20 VSS.n19 5.2005
R125 VSS.n19 VSS.n8 2.66071
R126 VSS.n6 VSS.n14 5.2005
R127 VSS VSS.n6 5.2005
R128 VSS.n2 VSS 1.27115
R129 VSS.n25 VSS.n2 5.32092
R130 VSS.n24 VSS 5.2005
R131 VSS VSS.n7 5.2005
R132 VSS VSS.n1 1.27115
R133 VSS.n5 VSS.n15 4.5995
R134 VSS.n5 VSS.t2 4.4105
R135 VSS.n5 VSS.n3 1.42802
R136 VSS.n5 VSS.n4 2.71962
R137 VSS.n28 VSS.n0 2.66071
R138 VSS.n27 VSS.n26 2.66071
R139 VSS.n29 VSS.n7 2.66071
R140 VSS.n29 VSS.n1 5.32092
R141 VSS.n1 VSS.n0 5.32092
R142 VSS.n25 VSS.n24 2.66071
R143 VSS.n26 VSS.n2 5.32092
R144 VSS VSS.n3 2.07094
R145 VSS.n26 VSS.n12 1.27115
R146 VSS.n25 VSS.n12 1.27115
R147 VSS.n30 VSS.n29 1.27115
R148 VSS.n30 VSS.n0 1.27115
C0 A Y 0.5932f
C1 B a_193_203r# 0.12804f
C2 A B 0.13944f
C3 VDD Y 0.8309f
C4 VDD B 0.44577f
C5 VDD A 0.34923f
C6 Y VSS 0.6709f
C7 A VSS 0.93323f
C8 B VSS 0.94433f
C9 VDD VSS 3.18515f
C10 a_193_203r# VSS 0.1603f
C11 VDD.n1 VSS 0.14734f
C12 VDD.n30 VSS 0.17094f
C13 VDD.n33 VSS 0.17094f
C14 B.t0 VSS 0.28944f
C15 A.t0 VSS 0.4509f
C16 Y.t0 VSS 0.16271f
C17 Y.n0 VSS 0.11863f
C18 Y.n1 VSS 0.14504f
C19 Y.n2 VSS 0.44656f
.ends
