* NGSPICE file created from gf180mcu_ocd_sc_rt12t3v3__buf_1.ext - technology: gf180mcuD

.subckt gf180mcu_ocd_sc_rt12t3v3__buf_1 A Y VDD VSS
X0 VDD.t7 A.t1 a_193_203r# VDD.t6 pfet_03v3 ad=0.3341p pd=1.805u as=0.3341p ps=1.805u w=1.285u l=0.28u
X1 Y.t1 a_193_203r# VSS.t1 VSS.t0 nfet_03v3 ad=0.3087p pd=2.01u as=2.92382p ps=15.475u w=1.02u l=0.28u
X2 Y.t0 a_193_203r# VDD.t1 VDD.t0 pfet_03v3 ad=0.3341p pd=1.805u as=0.3341p ps=1.805u w=1.285u l=0.28u
X3 a_193_203r# A.t2 VDD.t5 VDD.t4 pfet_03v3 ad=0.3341p pd=1.805u as=0.5654p ps=3.45u w=1.285u l=0.28u
X4 VDD.t3 a_193_203r# Y.t2 VDD.t2 pfet_03v3 ad=0.5654p pd=3.45u as=0.3341p ps=1.805u w=1.285u l=0.28u
X5 a_193_203r# A.t0 VSS.t3 VSS.t2 nfet_03v3 ad=0.3087p pd=2.01u as=2.92382p ps=15.475u w=1.02u l=0.28u
R0 Y.t1 Y.n1 3.32853
R1 Y Y.n0 2.98717
R2 Y.n0 Y.t0 1.41684
R3 Y.n0 Y.t2 1.41684
R4 Y Y.t1 7.2141
R5 A.n0 A.t1 40.1505
R6 A.n0 A.t2 19.2934
R7 A A.n0 10.0207
R8 A A.t0 6.85756
R9 VDD.n34 VDD.n33 137.088
R10 VDD.n24 VDD.n22 137.088
R11 VDD.n26 VDD.n21 137.088
R12 VDD.n30 VDD.n16 137.088
R13 VDD.n32 VDD.n31 122.707
R14 VDD.n34 VDD.t4 117.504
R15 VDD.t2 VDD.n16 117.504
R16 VDD.n25 VDD.t6 97.9197
R17 VDD.t0 VDD.n25 97.9197
R18 VDD.t6 VDD.n24 39.1682
R19 VDD.n26 VDD.t0 39.1682
R20 VDD.n22 VDD.t4 19.5843
R21 VDD.n21 VDD.t2 19.5843
R22 VDD.n36 VDD.n35 9.8005
R23 VDD.n35 VDD.n6 2.75725
R24 VDD.n23 VDD.n8 9.8005
R25 VDD.n4 VDD.n20 2.75725
R26 VDD.n27 VDD.n20 9.8005
R27 VDD.n27 VDD.n18 9.8005
R28 VDD.n5 VDD.n18 2.75725
R29 VDD.n29 VDD.n28 9.8005
R30 VDD.n13 VDD.n10 9.8005
R31 VDD.n12 VDD.n11 9.8005
R32 VDD.n3 VDD.n17 4.93411
R33 VDD VDD.n36 6.3005
R34 VDD.n35 VDD.n34 6.3005
R35 VDD.n6 VDD 1.77287
R36 VDD.n22 VDD.n8 6.3005
R37 VDD.n6 VDD.n8 2.75725
R38 VDD.n24 VDD.n23 6.3005
R39 VDD.n23 VDD.n4 2.75725
R40 VDD.n25 VDD.n20 6.3005
R41 VDD.n4 VDD.n1 1.77287
R42 VDD.n27 VDD.n26 6.3005
R43 VDD.n1 VDD.n27 6.3005
R44 VDD.n21 VDD.n18 6.3005
R45 VDD.n1 VDD.n5 1.77287
R46 VDD.n28 VDD.n16 6.3005
R47 VDD.n28 VDD.n5 2.75725
R48 VDD.n30 VDD.n29 6.3005
R49 VDD.n29 VDD.n3 2.17736
R50 VDD.n31 VDD.n30 6.3005
R51 VDD.n1 VDD.n2 1.77287
R52 VDD.n3 VDD.n1 2.06282
R53 VDD.n11 VDD 6.3005
R54 VDD VDD.n12 6.3005
R55 VDD VDD.n13 6.3005
R56 VDD.n33 VDD.n10 6.3005
R57 VDD.n33 VDD.n32 6.3005
R58 VDD.n15 VDD.n0 5.4873
R59 VDD VDD.t5 4.32793
R60 VDD.n1 VDD.t3 4.32597
R61 VDD.n1 VDD.n19 2.91159
R62 VDD.n31 VDD.n0 2.82549
R63 VDD.n32 VDD.n14 2.82549
R64 VDD.n2 VDD.n15 5.514
R65 VDD.n2 VDD.n17 5.514
R66 VDD.n13 VDD.n9 2.75725
R67 VDD.n12 VDD.n9 2.75725
R68 VDD.n14 VDD.n10 2.73055
R69 VDD.n11 VDD.n7 2.17736
R70 VDD.n36 VDD.n7 2.17736
R71 VDD.n33 VDD.n7 2.06282
R72 VDD.n1 VDD.n0 2.03587
R73 VDD.n14 VDD 2.03587
R74 VDD.n30 VDD.n15 1.77287
R75 VDD.n30 VDD.n17 1.77287
R76 VDD.n33 VDD.n9 1.77287
R77 VDD.n1 VDD 1.7525
R78 VDD.n19 VDD.t7 1.41684
R79 VDD.n19 VDD.t1 1.41684
R80 VSS.n34 VSS.n33 513.399
R81 VSS.n20 VSS.n19 513.399
R82 VSS.n20 VSS.n18 513.399
R83 VSS.n24 VSS.n23 513.399
R84 VSS.n25 VSS.n24 513.399
R85 VSS.n25 VSS.n14 513.399
R86 VSS.n18 VSS.t0 472.144
R87 VSS.n34 VSS.t2 316.291
R88 VSS.n19 VSS.t2 197.109
R89 VSS.n31 VSS.n30 149.174
R90 VSS.n23 VSS.t0 41.2558
R91 VSS.n35 VSS.n13 10.8894
R92 VSS.n10 VSS.n9 2.64278
R93 VSS.n21 VSS.n16 10.4384
R94 VSS.n11 VSS.n16 2.57652
R95 VSS.n26 VSS.n12 9.94306
R96 VSS.n35 VSS.n6 9.76841
R97 VSS.n8 VSS.n13 7.38939
R98 VSS.n27 VSS.n9 7.29217
R99 VSS.n21 VSS.n5 2.35671
R100 VSS VSS.n31 5.41963
R101 VSS.n30 VSS 5.41963
R102 VSS.n22 VSS.n4 5.39809
R103 VSS.n35 VSS.n34 5.2005
R104 VSS VSS.n35 5.2005
R105 VSS.n33 VSS.n13 5.2005
R106 VSS.n13 VSS 5.2005
R107 VSS.n21 VSS.n20 5.2005
R108 VSS VSS.n5 1.074
R109 VSS.n19 VSS.n6 5.2005
R110 VSS.n6 VSS 5.2005
R111 VSS.n18 VSS.n16 5.2005
R112 VSS VSS.n11 1.31324
R113 VSS.n24 VSS.n12 5.2005
R114 VSS.n3 VSS.n12 1.67338
R115 VSS.n23 VSS.n22 5.2005
R116 VSS.n22 VSS.n11 2.57652
R117 VSS.n9 VSS.n14 5.2005
R118 VSS VSS.n10 1.28011
R119 VSS.n26 VSS.n25 5.2005
R120 VSS.n10 VSS.n26 2.64278
R121 VSS.n2 VSS 1.27115
R122 VSS.n28 VSS.n2 5.32092
R123 VSS.n27 VSS 5.2005
R124 VSS VSS.n8 5.2005
R125 VSS VSS.n1 1.27115
R126 VSS.n4 VSS.n15 4.5995
R127 VSS.n7 VSS.n17 4.5995
R128 VSS.n4 VSS.t1 4.4105
R129 VSS.n7 VSS.t3 4.4105
R130 VSS.n4 VSS.n3 1.07486
R131 VSS VSS.n3 1.3804
R132 VSS.n7 VSS.n5 1.42802
R133 VSS.n7 VSS.n6 2.71962
R134 VSS.n31 VSS.n0 2.66071
R135 VSS.n30 VSS.n29 2.66071
R136 VSS.n32 VSS.n8 2.66071
R137 VSS.n32 VSS.n1 5.32092
R138 VSS.n1 VSS.n0 5.32092
R139 VSS.n28 VSS.n27 2.66071
R140 VSS.n29 VSS.n2 5.32092
R141 VSS.n29 VSS.n14 1.27115
R142 VSS.n28 VSS.n14 1.27115
R143 VSS.n33 VSS.n32 1.27115
R144 VSS.n33 VSS.n0 1.27115
C0 Y a_193_203r# 0.46352f
C1 VDD a_193_203r# 0.69737f
C2 A VDD 0.44482f
C3 Y VDD 0.52711f
C4 A a_193_203r# 0.49065f
C5 Y VSS 0.84275f
C6 A VSS 0.97866f
C7 VDD VSS 3.18848f
C8 a_193_203r# VSS 0.59601f
C9 VDD.n1 VSS 0.15494f
C10 VDD.n16 VSS 0.10223f
C11 VDD.n30 VSS 0.17497f
C12 VDD.n33 VSS 0.17005f
C13 VDD.n34 VSS 0.10223f
C14 A.t0 VSS 0.35172f
C15 Y.t1 VSS 0.15904f
C16 Y.n1 VSS 0.16911f
.ends
