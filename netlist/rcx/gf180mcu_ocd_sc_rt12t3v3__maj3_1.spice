* NGSPICE file created from gf180mcu_ocd_sc_rt12t3v3__maj3_1.ext - technology: gf180mcuD

.subckt gf180mcu_ocd_sc_rt12t3v3__maj3_1 A B C Y VDD VSS
X0 a_884_987.t3 C.t3 a_208_231r.t4 VDD.t19 pfet_03v3 ad=0.5654p pd=3.45u as=0.3341p ps=1.805u w=1.285u l=0.28u
X1 a_208_231r.t5 C.t2 a_1652_987.t3 VDD.t20 pfet_03v3 ad=0.3341p pd=1.805u as=0.5654p ps=3.45u w=1.285u l=0.28u
X2 a_973_203r# A.t0 VSS.t6 VSS.t5 nfet_03v3 ad=0.3087p pd=2.01u as=4.32993p ps=24.5u w=1.02u l=0.28u
X3 a_92_987.t2 A.t3 a_208_231r.t1 VDD.t13 pfet_03v3 ad=0.3341p pd=1.805u as=0.3341p ps=1.805u w=1.285u l=0.28u
X4 a_1942_145# C a_208_231r# VSS nfet_03v3 ad=0.54405p pd=3.27u as=0.3087p ps=2.01u w=1.02u l=0.28u
X5 Y.t1 a_208_231r.t9 VDD.t11 VDD.t10 pfet_03v3 ad=0.3341p pd=1.805u as=0.5654p ps=3.45u w=1.285u l=0.28u
X6 a_208_231r.t2 C.t0 a_973_203r# VSS.t9 nfet_03v3 ad=0.3087p pd=2.01u as=0.52065p ps=3.23u w=1.02u l=0.28u
X7 VDD.t15 A.t2 a_1652_987.t0 VDD.t14 pfet_03v3 ad=0.3341p pd=1.805u as=0.3341p ps=1.805u w=1.285u l=0.28u
X8 VDD.t1 a_208_231r.t8 Y.t0 VDD.t0 pfet_03v3 ad=0.5654p pd=3.45u as=0.3341p ps=1.805u w=1.285u l=0.28u
X9 a_884_987.t1 B.t2 VDD.t9 VDD.t8 pfet_03v3 ad=0.3341p pd=1.805u as=0.3341p ps=1.805u w=1.285u l=0.28u
X10 a_1652_987.t2 C.t1 a_208_231r.t6 VDD.t21 pfet_03v3 ad=0.3341p pd=1.805u as=0.3341p ps=1.805u w=1.285u l=0.28u
X11 a_1942_145# B.t0 VSS.t1 VSS.t0 nfet_03v3 ad=0.3087p pd=2.015u as=3.24745p ps=18.375u w=1.02u l=0.28u
X12 VDD.t3 B.t5 a_92_987.t0 VDD.t2 pfet_03v3 ad=0.3341p pd=1.805u as=0.3341p ps=1.805u w=1.285u l=0.28u
X13 a_208_231r.t3 C.t4 a_884_987.t2 VDD.t18 pfet_03v3 ad=0.3341p pd=1.805u as=0.3341p ps=1.805u w=1.285u l=0.28u
X14 a_208_231r.t0 A.t4 a_92_987.t3 VDD.t12 pfet_03v3 ad=0.3341p pd=1.805u as=0.5654p ps=3.45u w=1.285u l=0.28u
X15 a_382_145# B.t1 VSS.t3 VSS.t2 nfet_03v3 ad=0.3087p pd=2.01u as=3.24745p ps=18.375u w=1.02u l=0.28u
X16 a_92_987.t1 B.t4 VDD.t5 VDD.t4 pfet_03v3 ad=0.5654p pd=3.45u as=0.3341p ps=1.805u w=1.285u l=0.28u
X17 a_1652_987.t1 A.t1 VDD.t17 VDD.t16 pfet_03v3 ad=0.5654p pd=3.45u as=0.3341p ps=1.805u w=1.285u l=0.28u
X18 a_382_145# A a_208_231r# VSS.t4 nfet_03v3 ad=0.52065p pd=3.23u as=0.3087p ps=2.01u w=1.02u l=0.28u
X19 Y.t2 a_208_231r.t7 VSS.t8 VSS.t7 nfet_03v3 ad=0.3087p pd=2.01u as=4.32993p ps=24.5u w=1.02u l=0.28u
X20 VDD.t7 B.t3 a_884_987.t0 VDD.t6 pfet_03v3 ad=0.3341p pd=1.805u as=0.5654p ps=3.45u w=1.285u l=0.28u
R0 Y.n6 Y.t2 50.9005
R1 Y.n2 Y.n7 32.5888
R2 Y.n7 Y.n6 16.9387
R3 Y.n6 Y.n0 11.9058
R4 Y Y.n3 6.65267
R5 Y.n3 Y.n0 3.31861
R6 Y.n7 Y.n4 3.6505
R7 Y Y.n5 2.92847
R8 Y.n2 Y.n0 0.0474974
R9 Y.n1 Y.t2 0.459182
R10 Y.n1 Y.n4 0.825727
R11 Y.n5 Y.t1 1.41684
R12 Y.n5 Y.t0 1.41684
R13 Y.n3 Y.t2 5.88322
R14 Y.n3 Y.n4 1.7588
R15 Y.n2 Y.n1 1.57306
R16 C.n0 C.t1 36.7633
R17 C.n3 C.t4 33.6456
R18 C.n3 C.t3 28.8818
R19 C.n0 C.t2 25.536
R20 C C.n2 10.0229
R21 C.n2 C.n1 8.0767
R22 C.n2 C.t0 7.58874
R23 C C.n3 4.0005
R24 C C.n0 3.12592
R25 B.n0 B.t2 31.1559
R26 B.n1 B.t5 31.0545
R27 B.n1 B.t4 23.7545
R28 B.n0 B.t3 23.6531
R29 B.n3 B.n2 9.61925
R30 B.n2 B.n0 4.49866
R31 B.n2 B.n1 4.26471
R32 B B.t0 7.22511
R33 B.n3 B.t1 7.25074
R34 B B.n3 2.03344
* Added this one. . .
RXXX1 A A.n0 0.01
R35 A.n3 A.t3 45.6255
R36 A.n0 A.t2 31.5614
R37 A.n3 A.t4 27.1148
R38 A.n0 A.t1 23.2475
R39 A.n4 A.n2 11.0895
R40 A.n1 A.n0 6.8808
R41 A.n4 A.n3 5.01439
R42 A.n1 A.t0 16.539
R43 A.n4 A.n1 1.1231
R44 VDD.n79 VDD.n78 411.361
R45 VDD.n81 VDD.n80 137.088
R46 VDD.n48 VDD.n47 137.088
R47 VDD.n52 VDD.n51 137.088
R48 VDD.n53 VDD.n44 137.088
R49 VDD.n57 VDD.n56 137.088
R50 VDD.n61 VDD.n39 137.088
R51 VDD.n63 VDD.n62 137.088
R52 VDD.n66 VDD.n36 137.088
R53 VDD.n68 VDD.n35 137.088
R54 VDD.n72 VDD.n71 137.088
R55 VDD.n73 VDD.n31 137.088
R56 VDD.n77 VDD.n27 137.088
R57 VDD.n44 VDD.t6 127.296
R58 VDD.n71 VDD.t16 127.296
R59 VDD.n81 VDD.t12 117.504
R60 VDD.n53 VDD.t4 117.504
R61 VDD.t0 VDD.n27 117.504
R62 VDD.n58 VDD.t18 107.712
R63 VDD.n62 VDD.t19 107.712
R64 VDD.n63 VDD.t20 107.712
R65 VDD.n67 VDD.t21 107.712
R66 VDD.t13 VDD.n46 97.9197
R67 VDD.n46 VDD.t2 97.9197
R68 VDD.t10 VDD.n72 97.9197
R69 VDD.n58 VDD.t8 88.1278
R70 VDD.t14 VDD.n67 88.1278
R71 VDD.t8 VDD.n57 48.9601
R72 VDD.n68 VDD.t14 48.9601
R73 VDD.n48 VDD.t13 39.1682
R74 VDD.n51 VDD.t2 39.1682
R75 VDD.n73 VDD.t10 39.1682
R76 VDD.t18 VDD.n39 29.3763
R77 VDD.t19 VDD.n61 29.3763
R78 VDD.t20 VDD.n36 29.3763
R79 VDD.t21 VDD.n66 29.3763
R80 VDD.n47 VDD.t12 19.5843
R81 VDD.t4 VDD.n52 19.5843
R82 VDD.n31 VDD.t0 19.5843
R83 VDD.n3 VDD.n26 5.514
R84 VDD.n83 VDD.n82 9.8005
R85 VDD.n5 VDD.n19 2.75725
R86 VDD.n49 VDD.n19 9.8005
R87 VDD.n7 VDD.n6 2.75725
R88 VDD.n50 VDD.n6 9.8005
R89 VDD.n17 VDD.n43 2.75725
R90 VDD.n54 VDD.n43 9.8005
R91 VDD.n9 VDD.n8 2.75725
R92 VDD.n55 VDD.n8 9.8005
R93 VDD.n16 VDD.n41 2.75725
R94 VDD.n59 VDD.n41 9.8005
R95 VDD.n59 VDD.n40 9.8005
R96 VDD.n60 VDD.n10 2.75725
R97 VDD.n60 VDD.n38 9.8005
R98 VDD.n64 VDD.n11 2.75725
R99 VDD.n64 VDD.n37 9.8005
R100 VDD.n65 VDD.n12 2.75725
R101 VDD.n65 VDD.n34 9.8005
R102 VDD.n69 VDD.n34 9.8005
R103 VDD.n69 VDD.n15 2.75725
R104 VDD.n70 VDD.n32 9.8005
R105 VDD.n13 VDD.n30 2.75725
R106 VDD.n74 VDD.n30 9.8005
R107 VDD.n74 VDD.n29 9.8005
R108 VDD.n14 VDD.n29 2.75725
R109 VDD.n76 VDD.n75 9.8005
R110 VDD.n24 VDD.n21 9.8005
R111 VDD.n23 VDD.n22 9.8005
R112 VDD.n56 VDD.t6 9.79242
R113 VDD.n35 VDD.t16 9.79242
R114 VDD.n4 VDD.n28 4.93411
R115 VDD VDD.n83 6.3005
R116 VDD.n82 VDD.n81 6.3005
R117 VDD.n82 VDD.n5 2.75725
R118 VDD.n47 VDD.n19 6.3005
R119 VDD VDD.n5 1.77287
R120 VDD.n49 VDD.n48 6.3005
R121 VDD.n7 VDD.n49 2.75725
R122 VDD.n46 VDD.n6 6.3005
R123 VDD VDD.n7 1.77287
R124 VDD.n51 VDD.n50 6.3005
R125 VDD.n50 VDD.n17 2.75725
R126 VDD.n52 VDD.n43 6.3005
R127 VDD.n17 VDD.n1 1.77287
R128 VDD.n54 VDD.n53 6.3005
R129 VDD.n9 VDD.n54 2.75725
R130 VDD.n44 VDD.n8 6.3005
R131 VDD.n1 VDD.n9 1.77287
R132 VDD.n56 VDD.n55 6.3005
R133 VDD.n55 VDD.n16 2.75725
R134 VDD.n57 VDD.n41 6.3005
R135 VDD.n16 VDD.n1 1.77287
R136 VDD.n59 VDD.n58 6.3005
R137 VDD.n1 VDD.n59 6.3005
R138 VDD.n40 VDD.n39 6.3005
R139 VDD.n10 VDD.n40 2.75725
R140 VDD.n61 VDD.n60 6.3005
R141 VDD.n10 VDD.n1 1.77287
R142 VDD.n62 VDD.n38 6.3005
R143 VDD.n38 VDD.n11 2.75725
R144 VDD.n64 VDD.n63 6.3005
R145 VDD.n1 VDD.n11 1.77287
R146 VDD.n37 VDD.n36 6.3005
R147 VDD.n12 VDD.n37 2.75725
R148 VDD.n66 VDD.n65 6.3005
R149 VDD.n12 VDD.n1 1.77287
R150 VDD.n67 VDD.n34 6.3005
R151 VDD.n34 VDD.n1 6.3005
R152 VDD.n69 VDD.n68 6.3005
R153 VDD.n1 VDD.n15 1.77287
R154 VDD.n35 VDD.n32 6.3005
R155 VDD.n15 VDD.n32 2.75725
R156 VDD.n71 VDD.n70 6.3005
R157 VDD.n70 VDD.n13 2.75725
R158 VDD.n72 VDD.n30 6.3005
R159 VDD.n13 VDD.n1 1.77287
R160 VDD.n74 VDD.n73 6.3005
R161 VDD.n1 VDD.n74 6.3005
R162 VDD.n31 VDD.n29 6.3005
R163 VDD.n1 VDD.n14 1.77287
R164 VDD.n75 VDD.n27 6.3005
R165 VDD.n75 VDD.n14 2.75725
R166 VDD.n77 VDD.n76 6.3005
R167 VDD.n76 VDD.n4 2.17736
R168 VDD.n78 VDD.n77 6.3005
R169 VDD.n3 VDD.n0 1.77287
R170 VDD.n4 VDD.n0 2.06282
R171 VDD.n22 VDD 6.3005
R172 VDD VDD.n23 6.3005
R173 VDD VDD.n24 6.3005
R174 VDD.n80 VDD.n21 6.3005
R175 VDD.n80 VDD.n79 6.3005
R176 VDD.n26 VDD.n2 5.4873
R177 VDD.n1 VDD.n33 5.42746
R178 VDD.n1 VDD.n42 5.42746
R179 VDD.n1 VDD.n45 5.42746
R180 VDD.n1 VDD.t1 4.32793
R181 VDD.n1 VDD.t11 4.32597
R182 VDD.n78 VDD.n2 2.82549
R183 VDD.n79 VDD.n25 2.82549
R184 VDD.n3 VDD.n28 5.514
R185 VDD.n24 VDD.n20 2.75725
R186 VDD.n23 VDD.n20 2.75725
R187 VDD.n25 VDD.n21 2.73055
R188 VDD.n22 VDD.n18 2.17736
R189 VDD.n83 VDD.n18 2.17736
R190 VDD.n80 VDD.n18 2.06282
R191 VDD.n0 VDD.n2 2.03587
R192 VDD.n25 VDD 2.03587
R193 VDD.n1 VDD 1.9685
R194 VDD.n77 VDD.n26 1.77287
R195 VDD.n77 VDD.n28 1.77287
R196 VDD.n80 VDD.n20 1.77287
R197 VDD.n33 VDD.t15 1.41684
R198 VDD.n33 VDD.t17 1.41684
R199 VDD.n42 VDD.t7 1.41684
R200 VDD.n42 VDD.t9 1.41684
R201 VDD.n45 VDD.t3 1.41684
R202 VDD.n45 VDD.t5 1.41684
R203 VDD.n1 VDD.n0 1.2965
R204 VSS.n82 VSS.n36 513.399
R205 VSS.n86 VSS.n85 513.399
R206 VSS.n87 VSS.n86 513.399
R207 VSS.n87 VSS.n34 513.399
R208 VSS.n51 VSS.n48 513.399
R209 VSS.n52 VSS.n51 513.399
R210 VSS.n53 VSS.n46 513.399
R211 VSS.n56 VSS.n46 513.399
R212 VSS.n57 VSS.n56 513.399
R213 VSS.n58 VSS.n44 513.399
R214 VSS.n61 VSS.n44 513.399
R215 VSS.n64 VSS.n63 513.399
R216 VSS.n64 VSS.n41 513.399
R217 VSS.n67 VSS.n41 513.399
R218 VSS.n69 VSS.n68 513.399
R219 VSS.n69 VSS.n40 513.399
R220 VSS.n73 VSS.n72 513.399
R221 VSS.n74 VSS.n73 513.399
R222 VSS.n74 VSS.n37 513.399
R223 VSS.n58 VSS.t9 485.897
R224 VSS.n80 VSS.n79 469.901
R225 VSS.n68 VSS.t0 435.474
R226 VSS.n48 VSS.t2 417.137
R227 VSS.n36 VSS.t4 316.291
R228 VSS.t5 VSS.n52 297.955
R229 VSS.n62 VSS.n61 284.204
R230 VSS.n40 VSS.t7 261.284
R231 VSS.n72 VSS.t7 252.117
R232 VSS.n63 VSS.n62 229.196
R233 VSS.n53 VSS.t5 215.445
R234 VSS.n85 VSS.t4 197.109
R235 VSS.t2 VSS.n34 96.2628
R236 VSS.t0 VSS.n67 77.9272
R237 VSS.t9 VSS.n57 27.504
R238 VSS.n75 VSS.n24 2.66071
R239 VSS.n70 VSS.n30 10.8894
R240 VSS.n18 VSS.n45 2.66071
R241 VSS.n59 VSS.n45 10.8894
R242 VSS.n20 VSS.n19 2.66071
R243 VSS.n60 VSS.n19 10.8894
R244 VSS.n21 VSS.n43 2.66071
R245 VSS.n65 VSS.n43 10.8894
R246 VSS.n23 VSS.n22 2.66071
R247 VSS.n50 VSS.n29 10.8894
R248 VSS.n83 VSS.n16 10.8894
R249 VSS.n84 VSS.n16 10.8894
R250 VSS.n17 VSS.n33 2.66071
R251 VSS.n88 VSS.n33 10.8894
R252 VSS.n75 VSS.n32 10.593
R253 VSS.n26 VSS.n13 2.62485
R254 VSS.n66 VSS.n22 10.5415
R255 VSS.n55 VSS.n31 10.49
R256 VSS.n54 VSS.n25 2.51264
R257 VSS.n28 VSS.n9 2.50574
R258 VSS.n27 VSS.n30 2.4988
R259 VSS.n50 VSS.n15 2.4988
R260 VSS.n8 VSS.n32 2.53355
R261 VSS.n14 VSS.n13 7.92821
R262 VSS.n66 VSS.n11 2.4771
R263 VSS.n83 VSS.n35 7.38939
R264 VSS.n76 VSS.n38 7.38939
R265 VSS.n6 VSS.n31 2.4182
R266 VSS.n1 VSS.n80 5.41963
R267 VSS.n79 VSS.n0 5.41963
R268 VSS.n88 VSS.n87 5.2005
R269 VSS.n26 VSS.n88 2.62485
R270 VSS.n86 VSS.n33 5.2005
R271 VSS.n17 VSS 1.27115
R272 VSS.n85 VSS.n84 5.2005
R273 VSS.n84 VSS.n17 2.66071
R274 VSS.n36 VSS.n16 5.2005
R275 VSS VSS.n16 5.2005
R276 VSS.n83 VSS.n82 5.2005
R277 VSS VSS.n83 5.2005
R278 VSS.n12 VSS.n48 5.2005
R279 VSS.n15 VSS.n12 2.4988
R280 VSS.n34 VSS.n13 5.2005
R281 VSS.n26 VSS 1.28908
R282 VSS.n52 VSS.n29 5.2005
R283 VSS.n25 VSS.n29 2.51264
R284 VSS.n51 VSS.n50 5.2005
R285 VSS.n15 VSS 1.3521
R286 VSS.n31 VSS.n46 5.2005
R287 VSS.n54 VSS.n53 5.2005
R288 VSS.n25 VSS 1.34518
R289 VSS.n22 VSS.n41 5.2005
R290 VSS.n0 VSS.n23 1.27115
R291 VSS.n65 VSS.n64 5.2005
R292 VSS.n23 VSS.n65 2.66071
R293 VSS.n63 VSS.n43 5.2005
R294 VSS.n21 VSS.n0 1.27115
R295 VSS.n61 VSS.n60 5.2005
R296 VSS.n60 VSS.n21 2.66071
R297 VSS.n19 VSS.n44 5.2005
R298 VSS.n0 VSS.n20 1.27115
R299 VSS.n59 VSS.n58 5.2005
R300 VSS.n20 VSS.n59 2.66071
R301 VSS.n57 VSS.n45 5.2005
R302 VSS.n18 VSS.n0 1.27115
R303 VSS.n56 VSS.n55 5.2005
R304 VSS.n55 VSS.n18 2.66071
R305 VSS.n68 VSS.n9 5.2005
R306 VSS.n0 VSS.n28 1.34863
R307 VSS.n67 VSS.n66 5.2005
R308 VSS.n11 VSS.n0 1.02858
R309 VSS.n40 VSS.n30 5.2005
R310 VSS.n0 VSS.n27 1.3521
R311 VSS.n70 VSS.n69 5.2005
R312 VSS.n28 VSS.n70 2.50574
R313 VSS.n73 VSS.n32 5.2005
R314 VSS.n72 VSS.n71 5.2005
R315 VSS.n71 VSS.n27 2.4988
R316 VSS.n38 VSS.n37 5.2005
R317 VSS.n24 VSS.n38 2.66071
R318 VSS.n75 VSS.n74 5.2005
R319 VSS.n0 VSS.n24 1.27115
R320 VSS.n4 VSS.n0 1.27115
R321 VSS.n77 VSS.n4 5.32092
R322 VSS.n76 VSS.n0 5.2005
R323 VSS.n35 VSS.n1 5.2005
R324 VSS.n1 VSS.n3 1.27115
R325 VSS.n7 VSS.t8 4.5995
R326 VSS.n10 VSS.t1 4.5995
R327 VSS.n14 VSS.t3 4.5995
R328 VSS.n5 VSS.t6 4.4105
R329 VSS VSS.n14 3.1505
R330 VSS.n6 VSS.n5 1.46527
R331 VSS.n11 VSS.n10 1.50094
R332 VSS.n8 VSS.n7 1.53514
R333 VSS.n5 VSS.n47 2.7725
R334 VSS.n80 VSS.n2 2.66071
R335 VSS.n79 VSS.n78 2.66071
R336 VSS.n81 VSS.n35 2.66071
R337 VSS.n81 VSS.n3 5.32092
R338 VSS.n3 VSS.n2 5.32092
R339 VSS.n77 VSS.n76 2.66071
R340 VSS.n78 VSS.n4 5.32092
R341 VSS.n7 VSS.n39 2.6465
R342 VSS.n10 VSS.n42 2.6465
R343 VSS.n14 VSS.n49 2.6465
R344 VSS.n5 VSS.n54 2.38227
R345 VSS.n0 VSS 2.0315
R346 VSS.n10 VSS.n9 1.98192
R347 VSS.n0 VSS.n8 1.82967
R348 VSS.n0 VSS 1.7495
R349 VSS.n14 VSS.n12 1.64457
R350 VSS.n71 VSS.n7 1.64457
R351 VSS.n78 VSS.n37 1.27115
R352 VSS.n77 VSS.n37 1.27115
R353 VSS.n82 VSS.n81 1.27115
R354 VSS.n82 VSS.n2 1.27115
R355 VSS.n0 VSS 1.26457
R356 VSS.n0 VSS 1.15326
R357 VSS VSS.n1 1.07488
R358 VSS.n0 VSS 1.07338
R359 VSS VSS.n6 1.0508
R360 a_1652_987.t1 a_1652_987.n1 4.91293
R361 a_1652_987.n1 a_1652_987.t3 4.89923
R362 a_1652_987.n1 a_1652_987.n0 2.6005
R363 a_1652_987.n0 a_1652_987.t0 1.41684
R364 a_1652_987.n0 a_1652_987.t2 1.41684
R365 a_884_987.n0 a_884_987.t0 4.91293
R366 a_884_987.n0 a_884_987.t3 4.89923
R367 a_884_987.n1 a_884_987.n0 2.6005
R368 a_884_987.n1 a_884_987.t2 1.41684
R369 a_884_987.t1 a_884_987.n1 1.41684
R370 a_92_987.t1 a_92_987.n1 4.91293
R371 a_92_987.n1 a_92_987.t3 4.89923
R372 a_92_987.n1 a_92_987.n0 2.6005
R373 a_92_987.n0 a_92_987.t0 1.41684
R374 a_92_987.n0 a_92_987.t2 1.41684
* Added this one too. . .
RXXX2 a_208_231r.n1 a_208_231r# 0.01
R375 a_208_231r.n1 a_208_231r.n5 1.68642
R376 a_208_231r.n1 a_208_231r.n2 0.152381
R377 a_208_231r.t2 a_208_231r.n4 1.68642
R378 a_208_231r.t2 a_208_231r.n3 0.152381
R379 a_208_231r.n17 a_208_231r.n12 85.0505
R380 a_208_231r.n23 a_208_231r.n22 85.0505
R381 a_208_231r.n7 a_208_231r.n23 47.2505
R382 a_208_231r.n9 a_208_231r.t9 38.9951
R383 a_208_231r.n9 a_208_231r.t8 38.7951
R384 a_208_231r.n28 a_208_231r.n24 23.1806
R385 a_208_231r.n16 a_208_231r.n13 18.4257
R386 a_208_231r.n26 a_208_231r.n25 16.9787
R387 a_208_231r.n1 a_208_231r.n14 14.7309
R388 a_208_231r.n20 a_208_231r.n19 11.6065
R389 a_208_231r.n31 a_208_231r.n30 11.5991
R390 a_208_231r.n32 a_208_231r.n6 11.5863
R391 a_208_231r.n20 a_208_231r.n11 10.3394
R392 a_208_231r.n33 a_208_231r.n32 10.3269
R393 a_208_231r.n31 a_208_231r.n21 10.3215
R394 a_208_231r.n27 a_208_231r.n7 10.2064
R395 a_208_231r.n8 a_208_231r.n6 2.87505
R396 a_208_231r.n28 a_208_231r.n27 8.8839
R397 a_208_231r.n27 a_208_231r.n26 8.64623
R398 a_208_231r.n32 a_208_231r.n0 6.45978
R399 a_208_231r.n15 a_208_231r.n14 5.4755
R400 a_208_231r.n0 a_208_231r.n31 4.5005
R401 a_208_231r.n0 a_208_231r.n20 4.5005
R402 a_208_231r.n10 a_208_231r.n9 4.34508
R403 a_208_231r.n2 a_208_231r.n15 5.38578
R404 a_208_231r.n18 a_208_231r.n13 3.6505
R405 a_208_231r.n15 a_208_231r.n13 14.9876
R406 a_208_231r.n25 a_208_231r.n3 5.38578
R407 a_208_231r.n29 a_208_231r.n28 3.1995
R408 a_208_231r.n18 a_208_231r.n17 3.1505
R409 a_208_231r.n29 a_208_231r.n23 3.1505
R410 a_208_231r.t2 a_208_231r.n7 3.1505
R411 a_208_231r.n19 a_208_231r.n1 2.93326
R412 a_208_231r.n30 a_208_231r.t2 2.93326
R413 a_208_231r.n17 a_208_231r.n16 2.86474
R414 a_208_231r.n10 a_208_231r.t7 8.77557
R415 a_208_231r.n26 a_208_231r.t2 2.04661
R416 a_208_231r.n25 a_208_231r.n24 1.92498
R417 a_208_231r.n2 a_208_231r.n12 3.86742
R418 a_208_231r.n18 a_208_231r.n5 0.0332878
R419 a_208_231r.n12 a_208_231r.n5 48.9364
R420 a_208_231r.n3 a_208_231r.n22 3.86742
R421 a_208_231r.n29 a_208_231r.n4 0.0332878
R422 a_208_231r.n22 a_208_231r.n4 48.9364
R423 a_208_231r.n0 a_208_231r.n10 1.98758
R424 a_208_231r.n16 a_208_231r.n1 1.71736
R425 a_208_231r.n19 a_208_231r.n12 1.62981
R426 a_208_231r.n30 a_208_231r.n22 1.62981
R427 a_208_231r.n33 a_208_231r.t0 1.41684
R428 a_208_231r.t1 a_208_231r.n33 1.41684
R429 a_208_231r.n11 a_208_231r.t5 1.41684
R430 a_208_231r.n11 a_208_231r.t6 1.41684
R431 a_208_231r.n21 a_208_231r.t3 1.41684
R432 a_208_231r.n21 a_208_231r.t4 1.41684
C0 B a_1942_145# 0.15636f
C1 VDD Y 0.55473f
C2 VDD B 0.67547f
C3 B a_382_145# 0.13271f
C4 C B 0.63707f
C5 C VDD 0.66171f
C6 Y VSS 0.98444f
C7 B VSS 2.05136f
C8 VDD VSS 8.46239f
C9 a_1942_145# VSS 1.13881f
C10 a_973_203r# VSS 0.91252f
C11 a_382_145# VSS 0.99759f
C12 a_208_231r.n0 VSS 1.05286f
C13 a_208_231r.n1 VSS 0.12613f
C14 a_208_231r.t2 VSS 0.26826f
C15 a_208_231r.n6 VSS 0.47547f
C16 a_208_231r.t0 VSS 0.15785f
C17 a_208_231r.n8 VSS 0.10548f
C18 a_208_231r.n9 VSS 0.24332f
C19 a_208_231r.n10 VSS 0.78797f
C20 a_208_231r.t6 VSS 0.13712f
C21 a_208_231r.t5 VSS 0.12609f
C22 a_208_231r.n11 VSS 0.21899f
C23 a_208_231r.n13 VSS 0.1211f
C24 a_208_231r.n20 VSS 0.67063f
C25 a_208_231r.t4 VSS 0.12775f
C26 a_208_231r.t3 VSS 0.13188f
C27 a_208_231r.n21 VSS 0.22913f
C28 a_208_231r.n24 VSS 0.12024f
C29 a_208_231r.n31 VSS 0.68274f
C30 a_208_231r.n32 VSS 0.79565f
C31 a_208_231r.n33 VSS 0.23052f
C32 a_208_231r.t1 VSS 0.18416f
C33 a_92_987.t3 VSS 0.37482f
C34 a_92_987.t0 VSS 0.17636f
C35 a_92_987.t2 VSS 0.20899f
C36 a_92_987.n0 VSS 0.17931f
C37 a_92_987.n1 VSS 0.7995f
C38 a_92_987.t1 VSS 0.36032f
C39 a_884_987.t2 VSS 0.15752f
C40 a_884_987.t3 VSS 0.34729f
C41 a_884_987.t0 VSS 0.36269f
C42 a_884_987.n0 VSS 0.8068f
C43 a_884_987.n1 VSS 0.18095f
C44 a_884_987.t1 VSS 0.17735f
C45 a_1652_987.t3 VSS 0.34511f
C46 a_1652_987.t0 VSS 0.19777f
C47 a_1652_987.t2 VSS 0.16259f
C48 a_1652_987.n0 VSS 0.18062f
C49 a_1652_987.n1 VSS 0.80531f
C50 a_1652_987.t1 VSS 0.37866f
C51 VSS.t8 VSS 0.34262f
C52 VSS.t1 VSS 0.32804f
C53 VSS.t3 VSS 0.32489f
C54 VSS.t6 VSS 0.5858f
C55 VDD.n1 VSS 0.59714f
C56 VDD.n27 VSS 0.149f
C57 VDD.t1 VSS 0.12225f
C58 VDD.t11 VSS 0.12254f
C59 VDD.t17 VSS 0.10539f
C60 VDD.t15 VSS 0.11918f
C61 VDD.n44 VSS 0.15473f
C62 VDD.n46 VSS 0.11462f
C63 VDD.n48 VSS 0.10315f
C64 VDD.n51 VSS 0.10315f
C65 VDD.n53 VSS 0.149f
C66 VDD.n57 VSS 0.10888f
C67 VDD.n58 VSS 0.11462f
C68 VDD.n62 VSS 0.14327f
C69 VDD.n63 VSS 0.14327f
C70 VDD.n67 VSS 0.11462f
C71 VDD.n68 VSS 0.10888f
C72 VDD.n71 VSS 0.15473f
C73 VDD.n72 VSS 0.13754f
C74 VDD.n73 VSS 0.10315f
C75 VDD.n77 VSS 0.24069f
C76 VDD.n78 VSS 0.12307f
C77 VDD.n79 VSS 0.12307f
C78 VDD.n80 VSS 0.26935f
C79 VDD.n81 VSS 0.149f
C80 A.n0 VSS 0.4699f
C81 A.n1 VSS 1.39897f
C82 A.n2 VSS 0.79562f
C83 A.n3 VSS 0.30025f
C84 A.n4 VSS 1.05394f
C85 B.n0 VSS 0.21649f
C86 B.n1 VSS 0.20923f
C87 B.n2 VSS 0.40252f
C88 B.n3 VSS 0.87997f
C89 C.n0 VSS 0.22614f
C90 C.n1 VSS 0.54818f
C91 C.n2 VSS 0.77975f
C92 C.n3 VSS 0.14887f
C93 Y.n2 VSS 0.11351f
C94 Y.t2 VSS 0.36617f
C95 Y.t0 VSS 0.15246f
C96 Y.t1 VSS 0.15276f
C97 Y.n5 VSS 0.13354f
C98 Y.n6 VSS 0.1052f
C99 Y.n7 VSS 0.15444f
.ends
