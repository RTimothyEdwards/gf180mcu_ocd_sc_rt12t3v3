* NGSPICE file created from gf180mcu_ocd_sc_rt12t3v3__xnor2_1.ext - technology: gf180mcuD

.subckt gf180mcu_ocd_sc_rt12t3v3__xnor2_1 A B Y VDD VSS
X0 VDD.t15 A.t4 AN.t2 VDD.t14 pfet_03v3 ad=0.5654p pd=3.45u as=0.3341p ps=1.805u w=1.285u l=0.28u
X1 VDD.t2 AN.t4 a_1313_987.t1 VDD.t1 pfet_03v3 ad=0.3341p pd=1.805u as=0.5654p ps=3.45u w=1.285u l=0.28u
X2 Y.t3 A.t3 a_540_987.t2 VDD.t18 pfet_03v3 ad=0.3341p pd=1.805u as=0.5654p ps=3.45u w=1.285u l=0.28u
X3 a_830_145# AN Y VSS nfet_03v3 ad=0.52065p pd=3.23u as=0.3087p ps=2.01u w=1.02u l=0.28u
X4 a_540_987.t1 B.t4 VDD.t11 VDD.t10 pfet_03v3 ad=0.5654p pd=3.45u as=0.3341p ps=1.805u w=1.285u l=0.28u
X5 a_1313_987.t3 AN.t3 VDD.t5 VDD.t4 pfet_03v3 ad=0.3341p pd=1.805u as=0.3341p ps=1.805u w=1.285u l=0.28u
X6 AN.t0 A.t1 VSS.t4 VSS.t1 nfet_03v3 ad=0.3087p pd=2.01u as=4.00512p ps=22.26u w=1.02u l=0.28u
X7 a_540_987.t3 A.t2 Y.t4 VDD.t19 pfet_03v3 ad=0.3341p pd=1.805u as=0.3341p ps=1.805u w=1.285u l=0.28u
X8 BN.t0 B.t0 VSS.t2 VSS.t1 nfet_03v3 ad=0.3087p pd=2.01u as=4.00512p ps=22.26u w=1.02u l=0.28u
X9 a_1411_203r# A.t0 VSS.t5 VSS.t1 nfet_03v3 ad=0.3087p pd=2.015u as=4.00512p ps=22.26u w=1.02u l=0.28u
X10 BN.t1 B.t3 VDD.t7 VDD.t6 pfet_03v3 ad=0.3341p pd=1.805u as=0.5654p ps=3.45u w=1.285u l=0.28u
X11 AN.t1 A.t5 VDD.t17 VDD.t16 pfet_03v3 ad=0.3341p pd=1.805u as=0.5654p ps=3.45u w=1.285u l=0.28u
X12 Y.t2 BN.t5 a_1313_987.t2 VDD.t3 pfet_03v3 ad=0.3341p pd=1.805u as=0.3341p ps=1.805u w=1.285u l=0.28u
X13 Y.t1 BN.t3 a_1411_203r# VSS.t0 nfet_03v3 ad=0.3087p pd=2.01u as=0.52065p ps=3.23u w=1.02u l=0.28u
X14 VDD.t9 B.t5 a_540_987.t0 VDD.t8 pfet_03v3 ad=0.3341p pd=1.805u as=0.3341p ps=1.805u w=1.285u l=0.28u
X15 a_830_145# B.t1 VSS.t3 VSS.t1 nfet_03v3 ad=0.3087p pd=2.01u as=4.00512p ps=22.26u w=1.02u l=0.28u
X16 a_1313_987.t0 BN.t4 Y.t0 VDD.t0 pfet_03v3 ad=0.5654p pd=3.45u as=0.3341p ps=1.805u w=1.285u l=0.28u
X17 VDD.t13 B.t2 BN.t2 VDD.t12 pfet_03v3 ad=0.5654p pd=3.45u as=0.3341p ps=1.805u w=1.285u l=0.28u
R0 Y.n3 Y.t1 11.7522
R1 Y.n3 Y.n1 10.3581
R2 Y Y.n0 5.83138
R3 Y Y.n3 5.28766
R4 Y.t1 Y.n2 3.1489
R5 Y.n0 Y.t3 1.41684
R6 Y.n0 Y.t4 1.41684
R7 Y.n1 Y.t2 1.41684
R8 Y.n1 Y.t0 1.41684
R9 B.n5 B.n4 109.177
R10 B.n6 B.n5 51.1005
R11 B.n0 B.t5 44.1771
R12 B.n2 B.t3 39.6951
R13 B.n2 B.t2 38.0951
R14 B.n0 B.t4 35.6604
R15 B.n8 B.n7 39.1228
R16 B.t0 B.n6 6.53409
R17 B.n7 B.n5 5.23239
R18 B B.n9 4.47255
R19 B.n1 B.n0 4.25571
R20 B B.n2 4.0005
R21 B.n8 B.n4 3.78086
R22 B.n9 B.n3 3.06173
R23 B.n7 B.t0 2.73523
R24 B.n4 B.n3 1.82502
R25 B.n9 B.n8 1.66288
R26 B.n6 B.n3 0.841386
R27 B.n1 B.t1 16.5029
R28 B B.n1 2.05705
R29 A.n0 A.t2 41.5588
R30 A.n1 A.t4 39.6951
R31 A.n1 A.t5 38.0951
R32 A.n0 A.t3 19.4766
R33 A A.n0 12.6999
R34 A A.t0 11.6438
R35 A A.t1 7.55542
R36 A A.n1 4.53147
R37 VDD.n68 VDD.n67 363.252
R38 VDD.n70 VDD.n69 137.088
R39 VDD.n41 VDD.n40 137.088
R40 VDD.n42 VDD.n39 137.088
R41 VDD.n46 VDD.n45 137.088
R42 VDD.n50 VDD.n35 137.088
R43 VDD.n52 VDD.n51 137.088
R44 VDD.n55 VDD.n32 137.088
R45 VDD.n57 VDD.n31 137.088
R46 VDD.n61 VDD.n60 137.088
R47 VDD.n62 VDD.n29 137.088
R48 VDD.n66 VDD.n25 137.088
R49 VDD.n60 VDD.t0 130.968
R50 VDD.n70 VDD.t16 117.504
R51 VDD.n39 VDD.t18 117.504
R52 VDD.n51 VDD.t10 117.504
R53 VDD.t12 VDD.n25 117.504
R54 VDD.n56 VDD.t4 111.383
R55 VDD.n52 VDD.t1 104.04
R56 VDD.n42 VDD.t14 97.9197
R57 VDD.n47 VDD.t19 97.9197
R58 VDD.n47 VDD.t8 97.9197
R59 VDD.t6 VDD.n61 97.9197
R60 VDD.t3 VDD.n56 84.4558
R61 VDD.n57 VDD.t3 52.6321
R62 VDD.t14 VDD.n41 39.1682
R63 VDD.t19 VDD.n46 39.1682
R64 VDD.t8 VDD.n35 39.1682
R65 VDD.n62 VDD.t6 39.1682
R66 VDD.t1 VDD.n32 33.0482
R67 VDD.t4 VDD.n55 25.7043
R68 VDD.n40 VDD.t16 19.5843
R69 VDD.n45 VDD.t18 19.5843
R70 VDD.t10 VDD.n50 19.5843
R71 VDD.n29 VDD.t12 19.5843
R72 VDD.n72 VDD.n71 9.8005
R73 VDD.n71 VDD.n13 2.75725
R74 VDD.n38 VDD.n19 9.8005
R75 VDD.n43 VDD.n38 9.8005
R76 VDD.n7 VDD.n6 2.75725
R77 VDD.n44 VDD.n6 9.8005
R78 VDD.n8 VDD.n37 2.75725
R79 VDD.n48 VDD.n37 9.8005
R80 VDD.n48 VDD.n17 9.8005
R81 VDD.n14 VDD.n17 2.75725
R82 VDD.n49 VDD.n34 9.8005
R83 VDD.n4 VDD.n34 2.75725
R84 VDD.n53 VDD.n16 9.8005
R85 VDD.n15 VDD.n16 2.75725
R86 VDD.n54 VDD.n30 9.8005
R87 VDD.n58 VDD.n30 9.8005
R88 VDD.n10 VDD.n9 2.75725
R89 VDD.n59 VDD.n9 9.8005
R90 VDD.n11 VDD.n28 2.75725
R91 VDD.n63 VDD.n28 9.8005
R92 VDD.n63 VDD.n27 9.8005
R93 VDD.n12 VDD.n27 2.75725
R94 VDD.n65 VDD.n64 9.8005
R95 VDD.n22 VDD.n21 9.8005
R96 VDD.n3 VDD.n18 4.93411
R97 VDD.n5 VDD.n26 4.93411
R98 VDD VDD.n72 6.3005
R99 VDD.n71 VDD.n70 6.3005
R100 VDD.n13 VDD 1.77287
R101 VDD.n40 VDD.n19 6.3005
R102 VDD.n13 VDD.n19 2.75725
R103 VDD.n41 VDD.n38 6.3005
R104 VDD.n38 VDD 6.3005
R105 VDD.n43 VDD.n42 6.3005
R106 VDD.n7 VDD.n43 2.75725
R107 VDD.n39 VDD.n6 6.3005
R108 VDD VDD.n7 1.77287
R109 VDD.n45 VDD.n44 6.3005
R110 VDD.n44 VDD.n8 2.75725
R111 VDD.n46 VDD.n37 6.3005
R112 VDD.n8 VDD 1.77287
R113 VDD.n48 VDD.n47 6.3005
R114 VDD VDD.n48 6.3005
R115 VDD.n17 VDD.n35 6.3005
R116 VDD VDD.n14 1.77287
R117 VDD.n50 VDD.n49 6.3005
R118 VDD.n49 VDD.n14 2.75725
R119 VDD.n51 VDD.n34 6.3005
R120 VDD.n4 VDD 1.77287
R121 VDD.n53 VDD.n52 6.3005
R122 VDD.n4 VDD.n53 2.75725
R123 VDD.n16 VDD.n32 6.3005
R124 VDD VDD.n15 1.77287
R125 VDD.n55 VDD.n54 6.3005
R126 VDD.n54 VDD.n15 2.75725
R127 VDD.n56 VDD.n30 6.3005
R128 VDD.n30 VDD.n1 6.3005
R129 VDD.n58 VDD.n57 6.3005
R130 VDD.n10 VDD.n58 2.75725
R131 VDD.n31 VDD.n9 6.3005
R132 VDD.n60 VDD.n59 6.3005
R133 VDD.n59 VDD.n11 2.75725
R134 VDD.n61 VDD.n28 6.3005
R135 VDD.n11 VDD.n1 1.77287
R136 VDD.n63 VDD.n62 6.3005
R137 VDD.n1 VDD.n63 6.3005
R138 VDD.n29 VDD.n27 6.3005
R139 VDD.n1 VDD.n12 1.77287
R140 VDD.n64 VDD.n25 6.3005
R141 VDD.n64 VDD.n12 2.75725
R142 VDD.n66 VDD.n65 6.3005
R143 VDD.n65 VDD.n5 2.17736
R144 VDD.n67 VDD.n66 6.3005
R145 VDD.n1 VDD.n2 1.77287
R146 VDD.n5 VDD.n1 2.06282
R147 VDD.n3 VDD 1.77287
R148 VDD VDD.n22 6.3005
R149 VDD.n69 VDD.n21 6.3005
R150 VDD.n69 VDD.n68 6.3005
R151 VDD.n31 VDD.t0 6.12045
R152 VDD.n24 VDD.n0 5.4873
R153 VDD VDD.n33 5.42746
R154 VDD VDD.n36 5.42746
R155 VDD.n1 VDD.t13 4.32793
R156 VDD VDD.t17 4.32793
R157 VDD.n1 VDD.t7 4.32597
R158 VDD VDD.t15 4.32597
R159 VDD.n67 VDD.n0 2.82549
R160 VDD.n68 VDD.n23 2.82549
R161 VDD.n2 VDD.n24 5.514
R162 VDD.n2 VDD.n26 5.514
R163 VDD.n22 VDD.n20 2.75725
R164 VDD.n3 VDD.n20 5.514
R165 VDD.n23 VDD.n21 2.73055
R166 VDD.n1 VDD.n10 2.64888
R167 VDD.n72 VDD.n18 2.17736
R168 VDD VDD.n1 2.1365
R169 VDD.n69 VDD.n18 2.06282
R170 VDD.n1 VDD.n0 2.03587
R171 VDD.n23 VDD 2.03587
R172 VDD.n66 VDD.n24 1.77287
R173 VDD.n66 VDD.n26 1.77287
R174 VDD.n69 VDD.n20 1.77287
R175 VDD.n33 VDD.t2 1.41684
R176 VDD.n33 VDD.t5 1.41684
R177 VDD.n36 VDD.t9 1.41684
R178 VDD.n36 VDD.t11 1.41684
R179 VSS.n35 VSS.n32 129.143
R180 VSS.n50 VSS.n21 129.078
R181 VSS.n38 VSS.n32 129.078
R182 VSS.t0 VSS.n21 70.3019
R183 VSS.n38 VSS.t1 56.4721
R184 VSS.n48 VSS.n23 10.8894
R185 VSS.n15 VSS.n11 5.159
R186 VSS.n8 VSS.n27 5.32092
R187 VSS.n45 VSS.n44 10.8894
R188 VSS.n52 VSS.n51 10.8894
R189 VSS.n37 VSS.n7 10.8894
R190 VSS.n37 VSS.n33 10.8894
R191 VSS.n40 VSS.n39 10.8894
R192 VSS.n39 VSS.n30 10.8894
R193 VSS.n17 VSS.n0 2.628
R194 VSS.n22 VSS.n14 5.28505
R195 VSS.n49 VSS.n19 2.4988
R196 VSS.n18 VSS.n3 2.4988
R197 VSS.n1 VSS.n0 8.09689
R198 VSS.n10 VSS.n9 7.92821
R199 VSS.n13 VSS.n46 7.92821
R200 VSS.n5 VSS.n20 5.15789
R201 VSS.n36 VSS.n35 7.81835
R202 VSS.n35 VSS.n34 7.81835
R203 VSS.n51 VSS.n7 7.38939
R204 VSS.n22 VSS.n6 4.82111
R205 VSS VSS.n52 5.2005
R206 VSS.n51 VSS.n50 5.2005
R207 VSS.n51 VSS 5.2005
R208 VSS.n50 VSS.n3 5.2005
R209 VSS VSS.n18 1.3521
R210 VSS.n5 VSS 1.00728
R211 VSS VSS.n45 5.2005
R212 VSS.n44 VSS 5.2005
R213 VSS.n8 VSS 1.27115
R214 VSS VSS.n12 1.63997
R215 VSS.n46 VSS 5.2005
R216 VSS.n15 VSS.n25 5.15552
R217 VSS.n15 VSS 1.27115
R218 VSS.n50 VSS.n0 5.2005
R219 VSS VSS.n17 1.2875
R220 VSS.n2 VSS 1.65749
R221 VSS.n19 VSS.n29 5.159
R222 VSS VSS.n16 1.27115
R223 VSS.n50 VSS.n23 5.2005
R224 VSS.n16 VSS.n23 2.66071
R225 VSS VSS.n48 5.2005
R226 VSS.n50 VSS.n9 5.2005
R227 VSS.n14 VSS.n9 2.62485
R228 VSS.n50 VSS.n49 5.2005
R229 VSS.n19 VSS 1.3521
R230 VSS VSS.n6 1.52105
R231 VSS VSS.n14 1.28908
R232 VSS.n32 VSS.n30 5.2005
R233 VSS.n39 VSS.n38 5.2005
R234 VSS.n39 VSS.n31 5.2005
R235 VSS.n40 VSS.n21 5.2005
R236 VSS.n40 VSS.n6 2.1609
R237 VSS.n21 VSS.n7 5.2005
R238 VSS VSS.n7 5.2005
R239 VSS.n38 VSS.n37 5.2005
R240 VSS.n37 VSS 5.2005
R241 VSS.n33 VSS.n32 5.2005
R242 VSS.n10 VSS.t2 4.5995
R243 VSS.n1 VSS.n47 4.5995
R244 VSS.n13 VSS.t3 4.5995
R245 VSS.n4 VSS.n43 4.5995
R246 VSS.n10 VSS.n41 4.4735
R247 VSS.n13 VSS.n42 4.4735
R248 VSS.n1 VSS.t5 4.4105
R249 VSS.n4 VSS.t4 4.4105
R250 VSS.n5 VSS.n4 1.53514
R251 VSS.n13 VSS.n12 0.51919
R252 VSS.n2 VSS.n1 0.491065
R253 VSS VSS.n10 3.1505
R254 VSS.n44 VSS.n28 2.66071
R255 VSS.n48 VSS.n24 2.66071
R256 VSS.n17 VSS.n24 5.28821
R257 VSS.n16 VSS.n29 5.32092
R258 VSS.n18 VSS.n27 5.159
R259 VSS.n8 VSS.n28 5.32092
R260 VSS.n34 VSS.n30 2.63361
R261 VSS.n36 VSS.n33 2.63361
R262 VSS.n45 VSS.n26 2.62485
R263 VSS.n46 VSS.n26 2.62485
R264 VSS.n52 VSS.n20 2.62485
R265 VSS.n12 VSS.n11 3.35472
R266 VSS.t1 VSS.t0 2.30546
R267 VSS.n4 VSS.n3 1.70757
R268 VSS.n49 VSS.n10 1.64457
R269 VSS.n2 VSS.n25 3.30481
R270 VSS VSS.n36 1.53032
R271 VSS.n34 VSS.n31 1.53032
R272 VSS.n50 VSS.n25 1.35384
R273 VSS.n50 VSS.n11 1.3521
R274 VSS.n50 VSS.n20 1.28908
R275 VSS.n50 VSS.n26 1.28908
R276 VSS.n50 VSS.n28 1.27115
R277 VSS.n50 VSS.n27 1.27115
R278 VSS.n50 VSS.n29 1.27115
R279 VSS.n50 VSS.n24 1.27115
R280 VSS.n50 VSS.n22 1.27115
R281 VSS.n31 VSS 1.22213
R282 a_1313_987.n1 a_1313_987.t1 4.91293
R283 a_1313_987.t0 a_1313_987.n1 4.89923
R284 a_1313_987.n1 a_1313_987.n0 2.6005
R285 a_1313_987.n0 a_1313_987.t2 1.41684
R286 a_1313_987.n0 a_1313_987.t3 1.41684
R287 a_540_987.n0 a_540_987.t1 4.91293
R288 a_540_987.n0 a_540_987.t2 4.89923
R289 a_540_987.n1 a_540_987.n0 2.6005
R290 a_540_987.t0 a_540_987.n1 1.41684
R291 a_540_987.n1 a_540_987.t3 1.41684
R292 BN.n2 BN.t5 39.2525
R293 BN.n2 BN.t4 19.2934
R294 BN.n0 BN.n2 16.1699
R295 BN.n0 BN.t3 12.9375
R296 BN BN.n1 3.95133
R297 BN.t0 BN.n3 3.32853
R298 BN.n1 BN.t1 1.41684
R299 BN.n1 BN.t2 1.41684
R300 BN.n0 BN.t0 7.00295
R301 BN BN.n0 1.5006
R302 AN.n1 AN.t3 31.1559
R303 AN.n1 AN.t4 23.6531
R304 AN AN.n1 16.2906
R305 AN.t0 AN.n2 3.32853
R306 AN.n0 AN.t1 1.41684
R307 AN.n0 AN.t2 1.41684
R308 AN AN.t0 7.00295
R309 AN AN.n0 4.75215
C0 Y VDD 0.24083f
C1 BN Y 0.38529f
C2 BN VDD 0.99189f
C3 B A 0.52076f
C4 Y AN 0.37078f
C5 VDD AN 1.01185f
C6 a_1411_203r# A 0.13759f
C7 a_830_145# B 0.12033f
C8 Y A 0.71079f
C9 VDD A 0.88034f
C10 Y B 0.57466f
C11 A AN 1.50477f
C12 B VDD 1.00324f
C13 BN B 1.22853f
C14 Y a_1411_203r# 0.19875f
C15 B AN 0.76027f
C16 Y VSS 1.77811f
C17 B VSS 1.6357f
C18 A VSS 2.69845f
C19 VDD VSS 7.90437f
C20 a_1411_203r# VSS 0.11236f
C21 a_830_145# VSS 0.10718f
C22 BN VSS 1.43412f
C23 AN VSS 3.4008f
C24 AN.t0 VSS 0.2625f
C25 AN.n0 VSS 0.25023f
C26 AN.t3 VSS 0.14579f
C27 AN.t4 VSS 0.12328f
C28 AN.n1 VSS 0.73769f
C29 AN.n2 VSS 0.2819f
C30 BN.n0 VSS 0.82069f
C31 BN.t0 VSS 0.18123f
C32 BN.n1 VSS 0.17276f
C33 BN.t3 VSS 0.45649f
C34 BN.t5 VSS 0.10477f
C35 BN.n2 VSS 0.29833f
C36 BN.n3 VSS 0.19462f
C37 a_540_987.t2 VSS 0.2742f
C38 a_540_987.t1 VSS 0.2753f
C39 a_540_987.n0 VSS 0.77793f
C40 a_540_987.n1 VSS 0.17448f
C41 a_1313_987.t1 VSS 0.27493f
C42 a_1313_987.n0 VSS 0.17424f
C43 a_1313_987.n1 VSS 0.7769f
C44 a_1313_987.t0 VSS 0.27384f
C45 VDD.n1 VSS 0.3144f
C46 VDD.n25 VSS 0.15298f
C47 VDD.n32 VSS 0.10223f
C48 VDD.n35 VSS 0.10591f
C49 VDD.n39 VSS 0.15298f
C50 VDD.n41 VSS 0.10591f
C51 VDD.n42 VSS 0.14121f
C52 VDD.n46 VSS 0.10591f
C53 VDD.n47 VSS 0.11768f
C54 VDD.n51 VSS 0.15298f
C55 VDD.n52 VSS 0.14489f
C56 VDD.n56 VSS 0.11768f
C57 VDD.n57 VSS 0.114f
C58 VDD.n60 VSS 0.16107f
C59 VDD.n61 VSS 0.14121f
C60 VDD.n62 VSS 0.10591f
C61 VDD.n66 VSS 0.24712f
C62 VDD.n67 VSS 0.11305f
C63 VDD.n68 VSS 0.11305f
C64 VDD.n69 VSS 0.27654f
C65 VDD.n70 VSS 0.15298f
C66 A.t2 VSS 0.12426f
C67 A.n0 VSS 0.18068f
C68 A.t4 VSS 0.12994f
C69 A.t5 VSS 0.12393f
C70 A.n1 VSS 0.21876f
C71 A.t1 VSS 0.69428f
C72 A.t0 VSS 0.64336f
C73 B.t4 VSS 0.12591f
C74 B.t5 VSS 0.14802f
C75 B.n0 VSS 0.26613f
C76 B.t1 VSS 0.97716f
C77 B.n1 VSS 0.6508f
C78 B.t2 VSS 0.12948f
C79 B.t3 VSS 0.13576f
C80 B.n2 VSS 0.22856f
C81 B.n6 VSS 0.11937f
C82 B.n7 VSS 0.26743f
C83 B.n8 VSS 0.37357f
C84 Y.t1 VSS 0.23337f
C85 Y.n0 VSS 0.13709f
C86 Y.n1 VSS 0.19011f
C87 Y.n2 VSS 0.10502f
C88 Y.n3 VSS 0.65167f
.ends
