* NGSPICE file created from gf180mcu_ocd_sc_rt12t3v3__xnor2_1.ext - technology: gf180mcuD

.subckt gf180mcu_ocd_sc_rt12t3v3__xnor2_1 A B Y VDD VSS
X0 VDD.t3 A.t4 AN.t1 VDD.t2 pfet_03v3 ad=0.5654p pd=3.45u as=0.3341p ps=1.805u w=1.285u l=0.28u
X1 VDD.t9 AN.t4 a_1313_987.t2 VDD.t8 pfet_03v3 ad=0.3341p pd=1.805u as=0.5654p ps=3.45u w=1.285u l=0.28u
X2 Y.t0 A.t3 a_540_987.t0 VDD.t6 pfet_03v3 ad=0.3341p pd=1.805u as=0.5654p ps=3.45u w=1.285u l=0.28u
X3 a_830_145# AN Y VSS nfet_03v3 ad=0.52065p pd=3.23u as=0.3087p ps=2.01u w=1.02u l=0.28u
X4 a_540_987.t3 B.t4 VDD.t17 VDD.t16 pfet_03v3 ad=0.5654p pd=3.45u as=0.3341p ps=1.805u w=1.285u l=0.28u
X5 a_1313_987.t3 AN.t3 VDD.t11 VDD.t10 pfet_03v3 ad=0.3341p pd=1.805u as=0.3341p ps=1.805u w=1.285u l=0.28u
X6 AN.t2 A.t1 VSS.t1 VSS.t0 nfet_03v3 ad=0.3087p pd=2.01u as=4.00512p ps=22.26u w=1.02u l=0.28u
X7 a_540_987.t1 A.t2 Y.t4 VDD.t7 pfet_03v3 ad=0.3341p pd=1.805u as=0.3341p ps=1.805u w=1.285u l=0.28u
X8 BN.t2 B.t0 VSS.t4 VSS.t0 nfet_03v3 ad=0.3087p pd=2.01u as=4.00512p ps=22.26u w=1.02u l=0.28u
X9 a_1411_203r# A.t0 VSS.t2 VSS.t0 nfet_03v3 ad=0.3087p pd=2.015u as=4.00512p ps=22.26u w=1.02u l=0.28u
X10 BN.t0 B.t3 VDD.t13 VDD.t12 pfet_03v3 ad=0.3341p pd=1.805u as=0.5654p ps=3.45u w=1.285u l=0.28u
X11 AN.t0 A.t5 VDD.t5 VDD.t4 pfet_03v3 ad=0.3341p pd=1.805u as=0.5654p ps=3.45u w=1.285u l=0.28u
X12 Y.t1 BN.t5 a_1313_987.t0 VDD.t0 pfet_03v3 ad=0.3341p pd=1.805u as=0.3341p ps=1.805u w=1.285u l=0.28u
X13 Y.t3 BN.t3 a_1411_203r# VSS.t3 nfet_03v3 ad=0.3087p pd=2.01u as=0.52065p ps=3.23u w=1.02u l=0.28u
X14 VDD.t15 B.t5 a_540_987.t2 VDD.t14 pfet_03v3 ad=0.3341p pd=1.805u as=0.3341p ps=1.805u w=1.285u l=0.28u
X15 a_830_145# B.t1 VSS.t5 VSS.t0 nfet_03v3 ad=0.3087p pd=2.01u as=4.00512p ps=22.26u w=1.02u l=0.28u
X16 a_1313_987.t1 BN.t4 Y.t2 VDD.t1 pfet_03v3 ad=0.5654p pd=3.45u as=0.3341p ps=1.805u w=1.285u l=0.28u
X17 VDD.t19 B.t2 BN.t1 VDD.t18 pfet_03v3 ad=0.5654p pd=3.45u as=0.3341p ps=1.805u w=1.285u l=0.28u
R0 Y.n0 Y.n2 1.68642
R1 Y.n0 Y.n1 0.152381
R2 Y.n13 Y.n9 88.7005
R3 Y.n16 Y.n6 85.0505
R4 Y.n25 Y.n20 85.0505
R5 Y.n9 Y.n6 47.2505
R6 Y.n17 Y.n16 47.2505
R7 Y.n24 Y.n21 18.4257
R8 Y.n10 Y.n8 17.0759
R9 Y Y.n27 16.1593
R10 Y.n13 Y.n12 15.5491
R11 Y.n0 Y.n22 14.7309
R12 Y.n23 Y.n21 13.736
R13 Y.n19 Y.n18 11.5868
R14 Y.n14 Y.n13 11.0809
R15 Y.n17 Y.n15 10.4505
R16 Y.n19 Y.n5 10.3581
R17 Y.n15 Y.n8 8.32713
R18 Y.n18 Y.t3 6.40912
R19 Y Y.n4 5.83138
R20 Y.n15 Y.n14 5.73172
R21 Y.n23 Y.n22 5.4755
R22 Y Y.n19 5.28766
R23 Y.n10 Y.n3 5.06743
R24 Y.n1 Y.n23 5.38578
R25 Y.n26 Y.n21 3.6505
R26 Y.n14 Y.n7 3.1505
R27 Y.n16 Y.n7 3.1505
R28 Y.t3 Y.n17 3.1505
R29 Y.n26 Y.n25 3.1505
R30 Y.n27 Y.n0 2.93326
R31 Y.n25 Y.n24 2.86474
R32 Y.t3 Y.n3 0.206238
R33 Y.t3 Y.n8 2.1221
R34 Y.t3 Y.n7 1.85912
R35 Y.n9 Y.n7 1.7505
R36 Y.n1 Y.n20 3.86742
R37 Y.n26 Y.n2 0.0332878
R38 Y.n20 Y.n2 48.9364
R39 Y.n24 Y.n0 1.71736
R40 Y.n18 Y.n6 1.62981
R41 Y.n27 Y.n20 1.62981
R42 Y.n3 Y.n6 3.88957
R43 Y.n4 Y.t0 1.41684
R44 Y.n4 Y.t4 1.41684
R45 Y.n5 Y.t1 1.41684
R46 Y.n5 Y.t2 1.41684
R47 Y.n12 Y.n11 1.32827
R48 Y.n12 Y.n10 1.16236
R49 B.n0 B.t5 44.1771
R50 B.n2 B.t3 39.6951
R51 B.n2 B.t2 38.0951
R52 B.n0 B.t4 35.6604
R53 B.n1 B.t1 16.9906
R54 B.n1 B.n0 4.25571
R55 B B.n2 4.0005
R56 B B.t0 8.58455
R57 B B.n1 2.05705
R58 A.n1 A.n0 2.50334
R59 A.n9 A.n8 124.1
R60 A.n2 A.t2 41.5588
R61 A.n3 A.t4 39.6951
R62 A.n3 A.t5 38.0951
R63 A.n11 A.n8 29.2005
R64 A.n7 A.n6 27.8461
R65 A.n2 A.t3 19.4766
R66 A A.n2 12.6999
R67 A.n13 A.n12 11.5588
R68 A.n12 A.n7 9.96489
R69 A.n14 A.n13 8.6736
R70 A.n13 A.n5 8.16955
R71 A.n10 A.n7 5.60586
R72 A A.n15 4.90745
R73 A.n8 A.n5 4.86717
R74 A A.t1 7.94065
R75 A A.n3 4.53147
R76 A.n6 A.n0 13.5619
R77 A.n14 A.n4 3.97515
R78 A.n9 A.n4 3.6505
R79 A.n10 A.n9 3.6505
R80 A.n12 A.n11 3.33676
R81 A.n15 A.n14 3.2125
R82 A.n14 A.n0 6.02051
R83 A.n15 A.n1 2.69287
R84 A.t0 A.n1 2.39646
R85 A.n11 A.n10 1.95586
R86 A.n5 A.n4 1.8255
R87 A.n6 A.t0 1.11195
R88 VDD.n68 VDD.n67 363.252
R89 VDD.n70 VDD.n69 137.088
R90 VDD.n41 VDD.n40 137.088
R91 VDD.n42 VDD.n39 137.088
R92 VDD.n46 VDD.n45 137.088
R93 VDD.n50 VDD.n35 137.088
R94 VDD.n52 VDD.n51 137.088
R95 VDD.n55 VDD.n32 137.088
R96 VDD.n57 VDD.n31 137.088
R97 VDD.n61 VDD.n60 137.088
R98 VDD.n62 VDD.n29 137.088
R99 VDD.n66 VDD.n25 137.088
R100 VDD.n60 VDD.t1 130.968
R101 VDD.n70 VDD.t4 117.504
R102 VDD.n39 VDD.t6 117.504
R103 VDD.n51 VDD.t16 117.504
R104 VDD.t18 VDD.n25 117.504
R105 VDD.n56 VDD.t10 111.383
R106 VDD.n52 VDD.t8 104.04
R107 VDD.n42 VDD.t2 97.9197
R108 VDD.n47 VDD.t7 97.9197
R109 VDD.n47 VDD.t14 97.9197
R110 VDD.t12 VDD.n61 97.9197
R111 VDD.t0 VDD.n56 84.4558
R112 VDD.n57 VDD.t0 52.6321
R113 VDD.t2 VDD.n41 39.1682
R114 VDD.t7 VDD.n46 39.1682
R115 VDD.t14 VDD.n35 39.1682
R116 VDD.n62 VDD.t12 39.1682
R117 VDD.t8 VDD.n32 33.0482
R118 VDD.t10 VDD.n55 25.7043
R119 VDD.n40 VDD.t4 19.5843
R120 VDD.n45 VDD.t6 19.5843
R121 VDD.t16 VDD.n50 19.5843
R122 VDD.n29 VDD.t18 19.5843
R123 VDD.n2 VDD.n24 5.514
R124 VDD.n72 VDD.n71 9.8005
R125 VDD.n71 VDD.n13 2.75725
R126 VDD.n38 VDD.n19 9.8005
R127 VDD.n43 VDD.n38 9.8005
R128 VDD.n7 VDD.n6 2.75725
R129 VDD.n44 VDD.n6 9.8005
R130 VDD.n8 VDD.n37 2.75725
R131 VDD.n48 VDD.n37 9.8005
R132 VDD.n48 VDD.n17 9.8005
R133 VDD.n14 VDD.n17 2.75725
R134 VDD.n49 VDD.n34 9.8005
R135 VDD.n4 VDD.n34 2.75725
R136 VDD.n53 VDD.n16 9.8005
R137 VDD.n15 VDD.n16 2.75725
R138 VDD.n54 VDD.n30 9.8005
R139 VDD.n58 VDD.n30 9.8005
R140 VDD.n10 VDD.n9 2.75725
R141 VDD.n59 VDD.n9 9.8005
R142 VDD.n11 VDD.n28 2.75725
R143 VDD.n63 VDD.n28 9.8005
R144 VDD.n63 VDD.n27 9.8005
R145 VDD.n12 VDD.n27 2.75725
R146 VDD.n65 VDD.n64 9.8005
R147 VDD.n22 VDD.n21 9.8005
R148 VDD.n3 VDD.n18 4.93411
R149 VDD.n5 VDD.n26 4.93411
R150 VDD VDD.n72 6.3005
R151 VDD.n71 VDD.n70 6.3005
R152 VDD.n13 VDD 1.77287
R153 VDD.n40 VDD.n19 6.3005
R154 VDD.n13 VDD.n19 2.75725
R155 VDD.n41 VDD.n38 6.3005
R156 VDD.n38 VDD 6.3005
R157 VDD.n43 VDD.n42 6.3005
R158 VDD.n7 VDD.n43 2.75725
R159 VDD.n39 VDD.n6 6.3005
R160 VDD VDD.n7 1.77287
R161 VDD.n45 VDD.n44 6.3005
R162 VDD.n44 VDD.n8 2.75725
R163 VDD.n46 VDD.n37 6.3005
R164 VDD.n8 VDD 1.77287
R165 VDD.n48 VDD.n47 6.3005
R166 VDD VDD.n48 6.3005
R167 VDD.n17 VDD.n35 6.3005
R168 VDD VDD.n14 1.77287
R169 VDD.n50 VDD.n49 6.3005
R170 VDD.n49 VDD.n14 2.75725
R171 VDD.n51 VDD.n34 6.3005
R172 VDD.n4 VDD 1.77287
R173 VDD.n53 VDD.n52 6.3005
R174 VDD.n4 VDD.n53 2.75725
R175 VDD.n16 VDD.n32 6.3005
R176 VDD VDD.n15 1.77287
R177 VDD.n55 VDD.n54 6.3005
R178 VDD.n54 VDD.n15 2.75725
R179 VDD.n56 VDD.n30 6.3005
R180 VDD.n30 VDD.n1 6.3005
R181 VDD.n58 VDD.n57 6.3005
R182 VDD.n10 VDD.n58 2.75725
R183 VDD.n31 VDD.n9 6.3005
R184 VDD.n60 VDD.n59 6.3005
R185 VDD.n59 VDD.n11 2.75725
R186 VDD.n61 VDD.n28 6.3005
R187 VDD.n11 VDD.n1 1.77287
R188 VDD.n63 VDD.n62 6.3005
R189 VDD.n1 VDD.n63 6.3005
R190 VDD.n29 VDD.n27 6.3005
R191 VDD.n1 VDD.n12 1.77287
R192 VDD.n64 VDD.n25 6.3005
R193 VDD.n64 VDD.n12 2.75725
R194 VDD.n66 VDD.n65 6.3005
R195 VDD.n65 VDD.n5 2.17736
R196 VDD.n67 VDD.n66 6.3005
R197 VDD.n2 VDD.n1 1.77287
R198 VDD.n5 VDD.n1 2.06282
R199 VDD.n3 VDD 1.77287
R200 VDD VDD.n22 6.3005
R201 VDD.n69 VDD.n21 6.3005
R202 VDD.n69 VDD.n68 6.3005
R203 VDD.n31 VDD.t1 6.12045
R204 VDD.n24 VDD.n0 5.4873
R205 VDD VDD.n33 5.42746
R206 VDD VDD.n36 5.42746
R207 VDD.n1 VDD.t19 4.32793
R208 VDD VDD.t5 4.32793
R209 VDD.n1 VDD.t13 4.32597
R210 VDD VDD.t3 4.32597
R211 VDD.n67 VDD.n0 2.82549
R212 VDD.n68 VDD.n23 2.82549
R213 VDD.n2 VDD.n26 5.514
R214 VDD.n22 VDD.n20 2.75725
R215 VDD.n3 VDD.n20 5.514
R216 VDD.n23 VDD.n21 2.73055
R217 VDD.n1 VDD.n10 2.64888
R218 VDD.n72 VDD.n18 2.17736
R219 VDD VDD.n1 2.1365
R220 VDD.n69 VDD.n18 2.06282
R221 VDD.n1 VDD.n0 2.03587
R222 VDD.n23 VDD 2.03587
R223 VDD.n66 VDD.n24 1.77287
R224 VDD.n66 VDD.n26 1.77287
R225 VDD.n69 VDD.n20 1.77287
R226 VDD.n33 VDD.t9 1.41684
R227 VDD.n33 VDD.t11 1.41684
R228 VDD.n36 VDD.t15 1.41684
R229 VDD.n36 VDD.t17 1.41684
R230 VSS.n35 VSS.n33 129.143
R231 VSS.n50 VSS.n23 129.078
R232 VSS.n38 VSS.n33 129.078
R233 VSS.t3 VSS.n23 70.3019
R234 VSS.n38 VSS.t0 56.4721
R235 VSS.n10 VSS.n1 5.28821
R236 VSS.n20 VSS.n19 2.66071
R237 VSS.n47 VSS.n19 10.8894
R238 VSS.n18 VSS.n14 5.159
R239 VSS.n9 VSS.n25 5.32092
R240 VSS.n44 VSS.n43 10.8894
R241 VSS.n52 VSS.n51 10.8894
R242 VSS.n37 VSS.n8 10.8894
R243 VSS.n37 VSS.n34 10.8894
R244 VSS.n39 VSS.n30 10.8894
R245 VSS.n39 VSS.n32 10.8894
R246 VSS.n21 VSS.n4 2.4988
R247 VSS.n12 VSS.n11 7.92821
R248 VSS.n16 VSS.n45 7.92821
R249 VSS.n6 VSS.n22 5.15789
R250 VSS.n36 VSS.n35 7.81835
R251 VSS.n35 VSS.n31 7.81835
R252 VSS.n51 VSS.n8 7.38939
R253 VSS.n49 VSS.n7 4.82111
R254 VSS VSS.n52 5.2005
R255 VSS.n51 VSS.n50 5.2005
R256 VSS.n51 VSS 5.2005
R257 VSS.n50 VSS.n4 5.2005
R258 VSS VSS.n21 1.3521
R259 VSS.n6 VSS 1.00728
R260 VSS VSS.n44 5.2005
R261 VSS.n43 VSS 5.2005
R262 VSS.n9 VSS 1.27115
R263 VSS VSS.n15 1.63997
R264 VSS.n45 VSS 5.2005
R265 VSS.n18 VSS 1.27115
R266 VSS VSS.n2 0.996963
R267 VSS.n46 VSS 5.2005
R268 VSS VSS.n47 5.2005
R269 VSS.n50 VSS.n19 5.2005
R270 VSS VSS.n20 1.27115
R271 VSS.n20 VSS.n29 5.32092
R272 VSS.n10 VSS 1.27115
R273 VSS.n50 VSS.n11 5.2005
R274 VSS.n17 VSS.n11 2.62485
R275 VSS.n13 VSS 1.63997
R276 VSS.n7 VSS 1.52105
R277 VSS VSS.n17 1.28908
R278 VSS.n33 VSS.n32 5.2005
R279 VSS.n39 VSS.n38 5.2005
R280 VSS.n0 VSS.n39 5.2005
R281 VSS.n30 VSS.n23 5.2005
R282 VSS.n7 VSS.n30 2.1609
R283 VSS.n23 VSS.n8 5.2005
R284 VSS VSS.n8 5.2005
R285 VSS.n38 VSS.n37 5.2005
R286 VSS.n37 VSS 5.2005
R287 VSS.n34 VSS.n33 5.2005
R288 VSS.n12 VSS.t4 4.5995
R289 VSS.n16 VSS.t5 4.5995
R290 VSS.n3 VSS.t2 4.4105
R291 VSS.n5 VSS.t1 4.4105
R292 VSS.n6 VSS.n5 1.53514
R293 VSS.n16 VSS.n15 0.51919
R294 VSS.n3 VSS.n2 1.55171
R295 VSS.n13 VSS.n12 0.51919
R296 VSS.n3 VSS.n40 2.7725
R297 VSS.n5 VSS.n42 2.7725
R298 VSS.n43 VSS.n26 2.66071
R299 VSS.n49 VSS.n17 5.28505
R300 VSS.n10 VSS.n29 5.32092
R301 VSS.n21 VSS.n25 5.159
R302 VSS.n9 VSS.n26 5.32092
R303 VSS.n12 VSS.n48 2.6465
R304 VSS.n16 VSS.n41 2.6465
R305 VSS.n32 VSS.n31 2.63361
R306 VSS.n36 VSS.n34 2.63361
R307 VSS.n2 VSS.n1 5.18841
R308 VSS.n45 VSS.n27 2.62485
R309 VSS.n44 VSS.n27 2.62485
R310 VSS.n52 VSS.n22 2.62485
R311 VSS.n47 VSS.n24 2.4988
R312 VSS.n15 VSS.n14 3.35472
R313 VSS.n46 VSS.n28 2.49531
R314 VSS.n18 VSS.n28 5.15552
R315 VSS.t0 VSS.t3 2.30546
R316 VSS.n13 VSS.n24 3.35472
R317 VSS.n5 VSS.n4 1.70757
R318 VSS.n3 VSS.n46 1.5389
R319 VSS VSS.n36 1.53032
R320 VSS.n0 VSS.n31 1.53032
R321 VSS.n50 VSS.n28 1.35384
R322 VSS.n50 VSS.n14 1.3521
R323 VSS.n50 VSS.n24 1.3521
R324 VSS.n50 VSS.n22 1.28908
R325 VSS.n50 VSS.n27 1.28908
R326 VSS.n50 VSS.n1 1.2875
R327 VSS.n50 VSS.n26 1.27115
R328 VSS.n50 VSS.n25 1.27115
R329 VSS.n50 VSS.n29 1.27115
R330 VSS.n50 VSS.n49 1.27115
R331 VSS VSS.n0 1.22213
R332 a_1313_987.n0 a_1313_987.t2 4.91293
R333 a_1313_987.n0 a_1313_987.t1 4.89923
R334 a_1313_987.n1 a_1313_987.n0 2.6005
R335 a_1313_987.t0 a_1313_987.n1 1.41684
R336 a_1313_987.n1 a_1313_987.t3 1.41684
R337 a_540_987.n0 a_540_987.t3 4.91293
R338 a_540_987.n0 a_540_987.t0 4.89923
R339 a_540_987.n1 a_540_987.n0 2.6005
R340 a_540_987.n1 a_540_987.t2 1.41684
R341 a_540_987.t1 a_540_987.n1 1.41684
R342 BN.n8 BN.t2 50.9005
R343 BN.n7 BN.t5 39.2525
R344 BN.n2 BN.n9 32.5888
R345 BN.n7 BN.t4 19.2934
R346 BN.n9 BN.n8 16.9387
R347 BN.n3 BN.n7 16.1699
R348 BN.n3 BN.t3 12.5664
R349 BN.n8 BN.n0 11.9058
R350 BN.n3 BN.n4 6.3005
R351 BN.n4 BN.n0 3.31861
R352 BN BN.n6 3.95133
R353 BN.n9 BN.n5 3.6505
R354 BN.n2 BN.n0 0.0474974
R355 BN.n1 BN.t2 0.459182
R356 BN.n1 BN.n5 0.825727
R357 BN.n6 BN.t0 1.41684
R358 BN.n6 BN.t1 1.41684
R359 BN.n4 BN.t2 5.88322
R360 BN.n4 BN.n5 1.7588
R361 BN.n2 BN.n1 1.57306
R362 BN BN.n3 1.5006
R363 AN.n9 AN.t2 50.9005
R364 AN.n3 AN.n10 32.5888
R365 AN.n7 AN.t3 31.1559
R366 AN.n7 AN.t4 23.6531
R367 AN.n10 AN.n9 16.9387
R368 AN.n0 AN.n7 15.33
R369 AN.n0 AN.n8 9.86868
R370 AN.n9 AN.n1 11.9058
R371 AN AN.n4 6.3005
R372 AN.n4 AN.n1 3.31861
R373 AN AN.n6 3.95133
R374 AN.n10 AN.n5 3.6505
R375 AN.n3 AN.n1 0.0474974
R376 AN.n2 AN.t2 0.459182
R377 AN.n2 AN.n5 0.825727
R378 AN.n6 AN.t0 1.41684
R379 AN.n6 AN.t1 1.41684
R380 AN.n4 AN.t2 5.88322
R381 AN AN.n0 1.76197
R382 AN.n4 AN.n5 1.7588
R383 AN.n3 AN.n2 1.57306
C0 VDD A 0.88034f
C1 B a_830_145# 0.12033f
C2 B BN 1.22853f
C3 Y BN 0.38529f
C4 B AN 0.76027f
C5 Y AN 0.37078f
C6 A AN 1.50477f
C7 Y B 0.57466f
C8 VDD BN 0.99189f
C9 B A 0.52076f
C10 Y A 0.71079f
C11 VDD AN 1.01185f
C12 Y a_1411_203r# 0.19875f
C13 a_1411_203r# A 0.13759f
C14 VDD B 1.00324f
C15 VDD Y 0.24083f
C16 Y VSS 2.19529f
C17 B VSS 1.83155f
C18 A VSS 2.28879f
C19 VDD VSS 7.90437f
C20 a_1411_203r# VSS 0.3591f
C21 a_830_145# VSS 1.45492f
C22 BN VSS 1.41795f
C23 AN.n0 VSS 0.94869f
C24 AN.n3 VSS 0.13383f
C25 AN.t2 VSS 0.34001f
C26 AN.t1 VSS 0.15624f
C27 AN.t0 VSS 0.15471f
C28 AN.n6 VSS 0.24074f
C29 AN.n7 VSS 0.61474f
C30 AN.n8 VSS 0.6617f
C31 AN.n9 VSS 0.12404f
C32 AN.n10 VSS 0.18209f
C33 BN.n3 VSS 0.76584f
C34 BN.t2 VSS 0.34676f
C35 BN.t1 VSS 0.13584f
C36 BN.t0 VSS 0.13745f
C37 BN.n6 VSS 0.16558f
C38 BN.n7 VSS 0.28594f
C39 BN.n9 VSS 0.12524f
C40 a_540_987.t2 VSS 0.18037f
C41 a_540_987.t0 VSS 0.33522f
C42 a_540_987.t3 VSS 0.35791f
C43 a_540_987.n0 VSS 0.77793f
C44 a_540_987.n1 VSS 0.17448f
C45 a_540_987.t1 VSS 0.16787f
C46 a_1313_987.t3 VSS 0.18414f
C47 a_1313_987.t1 VSS 0.32574f
C48 a_1313_987.t2 VSS 0.36112f
C49 a_1313_987.n0 VSS 0.7769f
C50 a_1313_987.n1 VSS 0.17424f
C51 a_1313_987.t0 VSS 0.15583f
C52 VSS.t5 VSS 0.45294f
C53 VSS.t1 VSS 0.31224f
C54 VSS.t4 VSS 0.32766f
C55 VDD.n1 VSS 0.3144f
C56 VDD.n25 VSS 0.15298f
C57 VDD.t19 VSS 0.11817f
C58 VDD.t13 VSS 0.11976f
C59 VDD.n32 VSS 0.10223f
C60 VDD.t11 VSS 0.10905f
C61 VDD.n35 VSS 0.10591f
C62 VDD.t15 VSS 0.10516f
C63 VDD.t3 VSS 0.11579f
C64 VDD.t5 VSS 0.11427f
C65 VDD.n39 VSS 0.15298f
C66 VDD.n41 VSS 0.10591f
C67 VDD.n42 VSS 0.14121f
C68 VDD.n46 VSS 0.10591f
C69 VDD.n47 VSS 0.11768f
C70 VDD.n51 VSS 0.15298f
C71 VDD.n52 VSS 0.14489f
C72 VDD.n56 VSS 0.11768f
C73 VDD.n57 VSS 0.114f
C74 VDD.n60 VSS 0.16107f
C75 VDD.n61 VSS 0.14121f
C76 VDD.n62 VSS 0.10591f
C77 VDD.n66 VSS 0.24712f
C78 VDD.n67 VSS 0.11305f
C79 VDD.n68 VSS 0.11305f
C80 VDD.n69 VSS 0.27654f
C81 VDD.n70 VSS 0.15298f
C82 A.n1 VSS 0.11866f
C83 A.n2 VSS 0.17149f
C84 A.n3 VSS 0.21893f
C85 A.n6 VSS 0.16432f
C86 A.n7 VSS 0.17999f
C87 A.n15 VSS 0.21251f
C88 B.n0 VSS 0.25331f
C89 B.n1 VSS 0.64364f
C90 B.n2 VSS 0.22938f
C91 Y.n0 VSS 0.10078f
C92 Y.t3 VSS 0.26198f
C93 Y.t4 VSS 0.13243f
C94 Y.t0 VSS 0.11282f
C95 Y.n4 VSS 0.11481f
C96 Y.t2 VSS 0.10371f
C97 Y.t1 VSS 0.12051f
C98 Y.n5 VSS 0.15922f
C99 Y.n19 VSS 0.54465f
C100 Y.n27 VSS 0.14063f
.ends
