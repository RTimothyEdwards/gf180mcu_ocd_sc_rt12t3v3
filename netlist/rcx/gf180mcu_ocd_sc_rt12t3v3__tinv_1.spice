* NGSPICE file created from gf180mcu_ocd_sc_rt12t3v3__tinv_1.ext - technology: gf180mcuD

.subckt gf180mcu_ocd_sc_rt12t3v3__tinv_1 A EN Y VDD VSS
X0 Y.t2 EN.t1 a_181_203r# VSS.t0 nfet_03v3 ad=0.3087p pd=2.01u as=0.52065p ps=3.23u w=1.02u l=0.28u
X1 a_92_987.t3 A.t1 VDD.t9 VDD.t8 pfet_03v3 ad=0.3341p pd=1.805u as=0.3341p ps=1.805u w=1.285u l=0.28u
X2 VDD.t5 EN.t2 EN_BAR.t2 VDD.t4 pfet_03v3 ad=0.5654p pd=3.45u as=0.3341p ps=1.805u w=1.285u l=0.28u
X3 Y.t1 EN_BAR.t4 a_92_987.t1 VDD.t1 pfet_03v3 ad=0.3341p pd=1.805u as=0.3341p ps=1.805u w=1.285u l=0.28u
X4 EN_BAR.t0 EN.t0 VSS.t2 VSS.t1 nfet_03v3 ad=0.3087p pd=2.01u as=3.57195p ps=19.96u w=1.02u l=0.28u
X5 VDD.t7 A.t2 a_92_987.t2 VDD.t6 pfet_03v3 ad=0.3341p pd=1.805u as=0.5654p ps=3.45u w=1.285u l=0.28u
X6 a_92_987.t0 EN_BAR.t3 Y.t0 VDD.t0 pfet_03v3 ad=0.5654p pd=3.45u as=0.3341p ps=1.805u w=1.285u l=0.28u
X7 EN_BAR.t1 EN.t3 VDD.t3 VDD.t2 pfet_03v3 ad=0.3341p pd=1.805u as=0.5654p ps=3.45u w=1.285u l=0.28u
X8 a_181_203r# A.t0 VSS.t4 VSS.t3 nfet_03v3 ad=0.3087p pd=2.01u as=3.57195p ps=19.96u w=1.02u l=0.28u
R0 Y Y.t2 6.54996
R1 Y Y.n0 5.44018
R2 Y.t2 Y.n1 3.1489
R3 Y.n0 Y.t0 1.41684
R4 Y.n0 Y.t1 1.41684
R5 EN.n0 EN.t3 50.4601
R6 EN.n0 EN.t2 30.8951
R7 EN EN.t1 17.0322
R8 EN EN.n0 8.53589
R9 EN EN.t0 11.3134
R10 A.n0 A.t1 31.1559
R11 A.n0 A.t2 23.6531
R12 A.t0 A 5.80982
R13 A A.n0 4.81773
R14 VDD.t6 VDD.n40 254.59
R15 VDD.n39 VDD.n38 186.852
R16 VDD.n41 VDD.n11 137.088
R17 VDD.n28 VDD.n26 137.088
R18 VDD.n32 VDD.n31 137.088
R19 VDD.n33 VDD.n23 137.088
R20 VDD.n37 VDD.n19 137.088
R21 VDD.n31 VDD.t0 117.504
R22 VDD.t4 VDD.n19 117.504
R23 VDD.n27 VDD.t8 97.9197
R24 VDD.t1 VDD.n27 97.9197
R25 VDD.t2 VDD.n32 97.9197
R26 VDD.t8 VDD.n11 39.1682
R27 VDD.n28 VDD.t1 39.1682
R28 VDD.n33 VDD.t2 39.1682
R29 VDD.n43 VDD.n42 19.6005
R30 VDD.n41 VDD.t6 19.5843
R31 VDD.n26 VDD.t0 19.5843
R32 VDD.n23 VDD.t4 19.5843
R33 VDD.n2 VDD.n18 5.514
R34 VDD.n42 VDD.n8 2.75725
R35 VDD.n25 VDD.n9 9.8005
R36 VDD.n29 VDD.n25 9.8005
R37 VDD.n5 VDD.n4 2.75725
R38 VDD.n30 VDD.n4 9.8005
R39 VDD.n6 VDD.n22 2.75725
R40 VDD.n34 VDD.n22 9.8005
R41 VDD.n34 VDD.n21 9.8005
R42 VDD.n7 VDD.n21 2.75725
R43 VDD.n36 VDD.n35 9.8005
R44 VDD.n16 VDD.n13 9.8005
R45 VDD.n15 VDD.n14 9.8005
R46 VDD.n3 VDD.n20 4.93411
R47 VDD VDD.n43 6.3005
R48 VDD.n42 VDD.n41 6.3005
R49 VDD.n8 VDD 1.77287
R50 VDD.n11 VDD.n9 6.3005
R51 VDD.n8 VDD.n9 2.75725
R52 VDD.n27 VDD.n25 6.3005
R53 VDD.n25 VDD 6.3005
R54 VDD.n29 VDD.n28 6.3005
R55 VDD.n5 VDD.n29 2.75725
R56 VDD.n26 VDD.n4 6.3005
R57 VDD VDD.n5 1.77287
R58 VDD.n31 VDD.n30 6.3005
R59 VDD.n30 VDD.n6 2.75725
R60 VDD.n32 VDD.n22 6.3005
R61 VDD.n6 VDD 1.77287
R62 VDD.n34 VDD.n33 6.3005
R63 VDD VDD.n34 6.3005
R64 VDD.n23 VDD.n21 6.3005
R65 VDD VDD.n7 1.77287
R66 VDD.n35 VDD.n19 6.3005
R67 VDD.n35 VDD.n7 2.75725
R68 VDD.n37 VDD.n36 6.3005
R69 VDD.n36 VDD.n3 2.17736
R70 VDD.n38 VDD.n37 6.3005
R71 VDD.n2 VDD.n0 1.77287
R72 VDD.n3 VDD.n0 2.06282
R73 VDD.n14 VDD 6.3005
R74 VDD VDD.n15 6.3005
R75 VDD VDD.n16 6.3005
R76 VDD.n40 VDD.n13 6.3005
R77 VDD.n40 VDD.n39 6.3005
R78 VDD.n18 VDD.n1 5.4873
R79 VDD VDD.n24 5.42746
R80 VDD VDD.t5 4.32793
R81 VDD VDD.t3 4.32597
R82 VDD.n38 VDD.n1 2.82549
R83 VDD.n39 VDD.n17 2.82549
R84 VDD.n2 VDD.n20 5.514
R85 VDD.n16 VDD.n12 2.75725
R86 VDD.n15 VDD.n12 2.75725
R87 VDD.n17 VDD.n13 2.73055
R88 VDD.n14 VDD.n10 2.17736
R89 VDD.n43 VDD.n10 2.17736
R90 VDD VDD.n0 2.0885
R91 VDD.n40 VDD.n10 2.06282
R92 VDD.n0 VDD.n1 2.03587
R93 VDD.n17 VDD 2.03587
R94 VDD.n37 VDD.n18 1.77287
R95 VDD.n37 VDD.n20 1.77287
R96 VDD.n40 VDD.n12 1.77287
R97 VDD.n24 VDD.t7 1.41684
R98 VDD.n24 VDD.t9 1.41684
R99 VSS.n42 VSS.t3 774.683
R100 VSS.n24 VSS.n23 513.399
R101 VSS.n24 VSS.n22 513.399
R102 VSS.n28 VSS.n27 513.399
R103 VSS.n29 VSS.n28 513.399
R104 VSS.n29 VSS.n19 513.399
R105 VSS.n33 VSS.n32 513.399
R106 VSS.n34 VSS.n33 513.399
R107 VSS.n34 VSS.n15 513.399
R108 VSS.n22 VSS.t0 504.231
R109 VSS.n19 VSS.t1 261.284
R110 VSS.n23 VSS.t3 252.117
R111 VSS.n32 VSS.t1 252.117
R112 VSS.n40 VSS.n39 220.447
R113 VSS.n43 VSS.n3 20.5027
R114 VSS.n35 VSS.n9 2.66071
R115 VSS.n26 VSS.n20 10.8894
R116 VSS.n26 VSS.n18 10.8894
R117 VSS.n30 VSS.n8 2.66071
R118 VSS.n30 VSS.n12 10.8894
R119 VSS.n35 VSS.n13 10.593
R120 VSS.n25 VSS.n10 2.62485
R121 VSS.n31 VSS.n11 2.4988
R122 VSS.n27 VSS.t0 9.16834
R123 VSS.n7 VSS.n13 2.53355
R124 VSS.n25 VSS.n5 7.92821
R125 VSS.n43 VSS.n14 7.38939
R126 VSS.n36 VSS.n16 7.38939
R127 VSS VSS.n40 5.41963
R128 VSS.n39 VSS 5.41963
R129 VSS.n43 VSS.n42 5.2005
R130 VSS VSS.n43 5.2005
R131 VSS.n25 VSS.n24 5.2005
R132 VSS VSS.n10 1.28908
R133 VSS.n23 VSS.n3 5.2005
R134 VSS.n4 VSS 1.6297
R135 VSS.n19 VSS.n12 5.2005
R136 VSS.n11 VSS.n12 2.4988
R137 VSS.n30 VSS.n29 5.2005
R138 VSS VSS.n8 1.27115
R139 VSS.n28 VSS.n18 5.2005
R140 VSS.n18 VSS.n8 2.66071
R141 VSS.n27 VSS.n26 5.2005
R142 VSS.n26 VSS 5.2005
R143 VSS.n22 VSS.n20 5.2005
R144 VSS.n10 VSS.n20 2.62485
R145 VSS.n33 VSS.n13 5.2005
R146 VSS.n32 VSS.n31 5.2005
R147 VSS.n11 VSS 1.3521
R148 VSS.n16 VSS.n15 5.2005
R149 VSS.n9 VSS.n16 2.66071
R150 VSS.n35 VSS.n34 5.2005
R151 VSS VSS.n9 1.27115
R152 VSS.n2 VSS 1.27115
R153 VSS.n37 VSS.n2 5.32092
R154 VSS.n36 VSS 5.2005
R155 VSS.n14 VSS 5.2005
R156 VSS.n6 VSS.t2 4.5995
R157 VSS.n5 VSS.n21 4.5995
R158 VSS.n6 VSS.n17 4.4735
R159 VSS.n5 VSS.t4 4.4105
R160 VSS.n5 VSS.n4 0.535676
R161 VSS.n7 VSS.n6 1.53514
R162 VSS.n40 VSS.n0 2.66071
R163 VSS.n39 VSS.n38 2.66071
R164 VSS.n41 VSS.n14 2.66071
R165 VSS.n41 VSS.n1 5.32092
R166 VSS.n1 VSS.n0 5.32092
R167 VSS.n37 VSS.n36 2.66071
R168 VSS.n38 VSS.n2 5.32092
R169 VSS VSS.n1 1.90715
R170 VSS.n4 VSS.n3 0.88364
R171 VSS.n31 VSS.n6 1.64457
R172 VSS.n38 VSS.n15 1.27115
R173 VSS.n37 VSS.n15 1.27115
R174 VSS.n42 VSS.n41 1.27115
R175 VSS.n42 VSS.n0 1.27115
R176 VSS VSS.n7 1.00728
R177 a_92_987.n1 a_92_987.t2 4.91293
R178 a_92_987.t0 a_92_987.n1 4.89923
R179 a_92_987.n1 a_92_987.n0 2.6005
R180 a_92_987.n0 a_92_987.t1 1.41684
R181 a_92_987.n0 a_92_987.t3 1.41684
R182 EN_BAR.n0 EN_BAR.t4 40.9773
R183 EN_BAR.n0 EN_BAR.t3 19.7745
R184 EN_BAR.n2 EN_BAR.n0 11.2325
R185 EN_BAR.t0 EN_BAR.n3 3.32853
R186 EN_BAR.n2 EN_BAR.n1 2.90767
R187 EN_BAR.n1 EN_BAR.t1 1.41684
R188 EN_BAR.n1 EN_BAR.t2 1.41684
R189 EN_BAR EN_BAR.t0 7.80377
R190 EN_BAR EN_BAR.n2 1.04415
C0 VDD A 0.45132f
C1 A a_181_203r# 0.1398f
C2 Y EN 0.16236f
C3 EN_BAR Y 0.10955f
C4 Y a_181_203r# 0.12927f
C5 A Y 0.11242f
C6 VDD EN 0.45659f
C7 VDD EN_BAR 0.99521f
C8 EN_BAR EN 0.77293f
C9 Y VSS 0.476f
C10 EN VSS 1.45971f
C11 A VSS 1.0158f
C12 VDD VSS 4.62707f
C13 a_181_203r# VSS 0.1485f
C14 EN_BAR VSS 0.86488f
C15 EN_BAR.t0 VSS 0.24046f
C16 EN_BAR.t4 VSS 0.13085f
C17 EN_BAR.n0 VSS 0.16279f
C18 EN_BAR.n1 VSS 0.1406f
C19 EN_BAR.n2 VSS 0.46286f
C20 EN_BAR.n3 VSS 0.24429f
C21 a_92_987.t2 VSS 0.25925f
C22 a_92_987.n0 VSS 0.16431f
C23 a_92_987.n1 VSS 0.73259f
C24 a_92_987.t0 VSS 0.25822f
C25 VDD.n19 VSS 0.13757f
C26 VDD.n27 VSS 0.10582f
C27 VDD.n31 VSS 0.13757f
C28 VDD.n32 VSS 0.12698f
C29 VDD.n37 VSS 0.22222f
C30 VDD.n40 VSS 0.31217f
C31 VDD.t6 VSS 0.14815f
C32 A.n0 VSS 0.1231f
C33 A.t0 VSS 0.3637f
C34 EN.n0 VSS 0.10186f
C35 EN.t1 VSS 0.35042f
C36 EN.t0 VSS 0.29476f
C37 Y.t2 VSS 0.13411f
.ends
