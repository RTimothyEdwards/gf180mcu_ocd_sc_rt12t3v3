* NGSPICE file created from gf180mcu_ocd_sc_rt12t3v3__tinv_1.ext - technology: gf180mcuD

.subckt gf180mcu_ocd_sc_rt12t3v3__tinv_1 A EN Y VDD VSS
X0 Y.t2 EN.t1 a_181_203r# VSS.t2 nfet_03v3 ad=0.3087p pd=2.01u as=0.52065p ps=3.23u w=1.02u l=0.28u
X1 a_92_987.t2 A.t1 VDD.t4 VDD.t3 pfet_03v3 ad=0.3341p pd=1.805u as=0.3341p ps=1.805u w=1.285u l=0.28u
X2 VDD.t9 EN.t2 EN_BAR.t2 VDD.t8 pfet_03v3 ad=0.5654p pd=3.45u as=0.3341p ps=1.805u w=1.285u l=0.28u
X3 Y.t1 EN_BAR.t4 a_92_987.t3 VDD.t5 pfet_03v3 ad=0.3341p pd=1.805u as=0.3341p ps=1.805u w=1.285u l=0.28u
X4 EN_BAR.t0 EN.t0 VSS.t4 VSS.t3 nfet_03v3 ad=0.3087p pd=2.01u as=3.57195p ps=19.96u w=1.02u l=0.28u
X5 VDD.t2 A.t2 a_92_987.t1 VDD.t1 pfet_03v3 ad=0.3341p pd=1.805u as=0.5654p ps=3.45u w=1.285u l=0.28u
X6 a_92_987.t0 EN_BAR.t3 Y.t0 VDD.t0 pfet_03v3 ad=0.5654p pd=3.45u as=0.3341p ps=1.805u w=1.285u l=0.28u
X7 EN_BAR.t1 EN.t3 VDD.t7 VDD.t6 pfet_03v3 ad=0.3341p pd=1.805u as=0.5654p ps=3.45u w=1.285u l=0.28u
X8 a_181_203r# A.t0 VSS.t1 VSS.t0 nfet_03v3 ad=0.3087p pd=2.01u as=3.57195p ps=19.96u w=1.02u l=0.28u
R0 Y.n9 Y.n5 88.7005
R1 Y.n12 Y.n2 85.0505
R2 Y.n5 Y.n2 47.2505
R3 Y.n13 Y.n12 47.2505
R4 Y.n6 Y.n4 17.0759
R5 Y.n9 Y.n8 15.5491
R6 Y.n10 Y.n9 11.0809
R7 Y.n13 Y.n11 10.4505
R8 Y.n11 Y.n4 8.32713
R9 Y.n14 Y.t2 6.40912
R10 Y Y.n14 6.38463
R11 Y.n11 Y.n10 5.73172
R12 Y Y.n1 5.44018
R13 Y.n6 Y.n0 5.06743
R14 Y.n10 Y.n3 3.1505
R15 Y.n12 Y.n3 3.1505
R16 Y.t2 Y.n13 3.1505
R17 Y.t2 Y.n0 0.206238
R18 Y.t2 Y.n4 2.1221
R19 Y.t2 Y.n3 1.85912
R20 Y.n5 Y.n3 1.7505
R21 Y.n14 Y.n2 1.62981
R22 Y.n0 Y.n2 3.88957
R23 Y.n1 Y.t1 1.41684
R24 Y.n1 Y.t0 1.41684
R25 Y.n8 Y.n7 1.32827
R26 Y.n8 Y.n6 1.16236
R27 EN.n12 EN.n11 149.65
R28 EN.n4 EN.t3 50.4601
R29 EN.n14 EN.n13 36.1777
R30 EN.n4 EN.t2 30.8951
R31 EN.n6 EN.n5 10.9833
R32 EN.n11 EN.n10 10.0787
R33 EN.n8 EN.n7 9.49726
R34 EN.n7 EN.n5 8.74185
R35 EN EN.n8 8.67159
R36 EN EN.n4 8.53589
R37 EN.n5 EN.n3 26.5867
R38 EN.n2 EN.n6 6.40171
R39 EN.t1 EN.n3 2.79935
R40 EN.n8 EN.n0 6.20821
R41 EN.n14 EN.n10 5.85149
R42 EN.t1 EN.n0 5.67388
R43 EN EN.n15 4.47255
R44 EN.n13 EN.n11 4.27703
R45 EN.n2 EN.n3 1.72589
R46 EN.n7 EN.n1 0.726598
R47 EN.n15 EN.n9 3.1756
R48 EN.n15 EN.n14 2.67476
R49 EN.t0 EN.n12 2.39605
R50 EN.n10 EN.n9 1.92197
R51 EN.n6 EN.n1 1.88877
R52 EN.n13 EN.t0 1.11195
R53 EN.n12 EN.n9 0.793248
R54 EN.n0 EN.n2 3.8
R55 EN.n0 EN.n1 2.2617
R56 A.n0 A.t1 31.1559
R57 A.n0 A.t2 23.6531
R58 A A.t0 6.15316
R59 A A.n0 4.81773
R60 VDD.t1 VDD.n40 254.59
R61 VDD.n39 VDD.n38 186.852
R62 VDD.n41 VDD.n11 137.088
R63 VDD.n28 VDD.n26 137.088
R64 VDD.n32 VDD.n31 137.088
R65 VDD.n33 VDD.n23 137.088
R66 VDD.n37 VDD.n19 137.088
R67 VDD.n31 VDD.t0 117.504
R68 VDD.t8 VDD.n19 117.504
R69 VDD.n27 VDD.t3 97.9197
R70 VDD.t5 VDD.n27 97.9197
R71 VDD.t6 VDD.n32 97.9197
R72 VDD.t3 VDD.n11 39.1682
R73 VDD.n28 VDD.t5 39.1682
R74 VDD.n33 VDD.t6 39.1682
R75 VDD.n43 VDD.n42 19.6005
R76 VDD.n41 VDD.t1 19.5843
R77 VDD.n26 VDD.t0 19.5843
R78 VDD.n23 VDD.t8 19.5843
R79 VDD.n2 VDD.n18 5.514
R80 VDD.n42 VDD.n8 2.75725
R81 VDD.n25 VDD.n9 9.8005
R82 VDD.n29 VDD.n25 9.8005
R83 VDD.n5 VDD.n4 2.75725
R84 VDD.n30 VDD.n4 9.8005
R85 VDD.n6 VDD.n22 2.75725
R86 VDD.n34 VDD.n22 9.8005
R87 VDD.n34 VDD.n21 9.8005
R88 VDD.n7 VDD.n21 2.75725
R89 VDD.n36 VDD.n35 9.8005
R90 VDD.n16 VDD.n13 9.8005
R91 VDD.n15 VDD.n14 9.8005
R92 VDD.n3 VDD.n20 4.93411
R93 VDD VDD.n43 6.3005
R94 VDD.n42 VDD.n41 6.3005
R95 VDD.n8 VDD 1.77287
R96 VDD.n11 VDD.n9 6.3005
R97 VDD.n8 VDD.n9 2.75725
R98 VDD.n27 VDD.n25 6.3005
R99 VDD.n25 VDD 6.3005
R100 VDD.n29 VDD.n28 6.3005
R101 VDD.n5 VDD.n29 2.75725
R102 VDD.n26 VDD.n4 6.3005
R103 VDD VDD.n5 1.77287
R104 VDD.n31 VDD.n30 6.3005
R105 VDD.n30 VDD.n6 2.75725
R106 VDD.n32 VDD.n22 6.3005
R107 VDD.n6 VDD 1.77287
R108 VDD.n34 VDD.n33 6.3005
R109 VDD VDD.n34 6.3005
R110 VDD.n23 VDD.n21 6.3005
R111 VDD VDD.n7 1.77287
R112 VDD.n35 VDD.n19 6.3005
R113 VDD.n35 VDD.n7 2.75725
R114 VDD.n37 VDD.n36 6.3005
R115 VDD.n36 VDD.n3 2.17736
R116 VDD.n38 VDD.n37 6.3005
R117 VDD.n2 VDD.n0 1.77287
R118 VDD.n3 VDD.n0 2.06282
R119 VDD.n14 VDD 6.3005
R120 VDD VDD.n15 6.3005
R121 VDD VDD.n16 6.3005
R122 VDD.n40 VDD.n13 6.3005
R123 VDD.n40 VDD.n39 6.3005
R124 VDD.n18 VDD.n1 5.4873
R125 VDD VDD.n24 5.42746
R126 VDD VDD.t9 4.32793
R127 VDD VDD.t7 4.32597
R128 VDD.n38 VDD.n1 2.82549
R129 VDD.n39 VDD.n17 2.82549
R130 VDD.n2 VDD.n20 5.514
R131 VDD.n16 VDD.n12 2.75725
R132 VDD.n15 VDD.n12 2.75725
R133 VDD.n17 VDD.n13 2.73055
R134 VDD.n14 VDD.n10 2.17736
R135 VDD.n43 VDD.n10 2.17736
R136 VDD VDD.n0 2.0885
R137 VDD.n40 VDD.n10 2.06282
R138 VDD.n0 VDD.n1 2.03587
R139 VDD.n17 VDD 2.03587
R140 VDD.n37 VDD.n18 1.77287
R141 VDD.n37 VDD.n20 1.77287
R142 VDD.n40 VDD.n12 1.77287
R143 VDD.n24 VDD.t2 1.41684
R144 VDD.n24 VDD.t4 1.41684
R145 VSS.n42 VSS.t0 774.683
R146 VSS.n24 VSS.n23 513.399
R147 VSS.n24 VSS.n22 513.399
R148 VSS.n28 VSS.n27 513.399
R149 VSS.n29 VSS.n28 513.399
R150 VSS.n29 VSS.n19 513.399
R151 VSS.n33 VSS.n32 513.399
R152 VSS.n34 VSS.n33 513.399
R153 VSS.n34 VSS.n15 513.399
R154 VSS.n22 VSS.t2 504.231
R155 VSS.n19 VSS.t3 261.284
R156 VSS.n23 VSS.t0 252.117
R157 VSS.n32 VSS.t3 252.117
R158 VSS.n40 VSS.n39 220.447
R159 VSS.n43 VSS.n3 20.5027
R160 VSS.n35 VSS.n9 2.66071
R161 VSS.n26 VSS.n20 10.8894
R162 VSS.n26 VSS.n18 10.8894
R163 VSS.n30 VSS.n8 2.66071
R164 VSS.n30 VSS.n12 10.8894
R165 VSS.n35 VSS.n13 10.593
R166 VSS.n25 VSS.n10 2.62485
R167 VSS.n31 VSS.n11 2.4988
R168 VSS.n27 VSS.t2 9.16834
R169 VSS.n7 VSS.n13 2.53355
R170 VSS.n25 VSS.n5 7.92821
R171 VSS.n43 VSS.n14 7.38939
R172 VSS.n36 VSS.n16 7.38939
R173 VSS VSS.n40 5.41963
R174 VSS.n39 VSS 5.41963
R175 VSS.n43 VSS.n42 5.2005
R176 VSS VSS.n43 5.2005
R177 VSS.n25 VSS.n24 5.2005
R178 VSS VSS.n10 1.28908
R179 VSS.n23 VSS.n3 5.2005
R180 VSS.n4 VSS 1.6297
R181 VSS.n19 VSS.n12 5.2005
R182 VSS.n11 VSS.n12 2.4988
R183 VSS.n30 VSS.n29 5.2005
R184 VSS VSS.n8 1.27115
R185 VSS.n28 VSS.n18 5.2005
R186 VSS.n18 VSS.n8 2.66071
R187 VSS.n27 VSS.n26 5.2005
R188 VSS.n26 VSS 5.2005
R189 VSS.n22 VSS.n20 5.2005
R190 VSS.n10 VSS.n20 2.62485
R191 VSS.n33 VSS.n13 5.2005
R192 VSS.n32 VSS.n31 5.2005
R193 VSS.n11 VSS 1.3521
R194 VSS.n16 VSS.n15 5.2005
R195 VSS.n9 VSS.n16 2.66071
R196 VSS.n35 VSS.n34 5.2005
R197 VSS VSS.n9 1.27115
R198 VSS.n2 VSS 1.27115
R199 VSS.n37 VSS.n2 5.32092
R200 VSS.n36 VSS 5.2005
R201 VSS.n14 VSS 5.2005
R202 VSS.n6 VSS.t4 4.5995
R203 VSS.n5 VSS.t1 4.4105
R204 VSS.n5 VSS.n4 0.535676
R205 VSS.n7 VSS.n6 1.53514
R206 VSS.n5 VSS.n21 2.7725
R207 VSS.n40 VSS.n0 2.66071
R208 VSS.n39 VSS.n38 2.66071
R209 VSS.n41 VSS.n14 2.66071
R210 VSS.n41 VSS.n1 5.32092
R211 VSS.n1 VSS.n0 5.32092
R212 VSS.n37 VSS.n36 2.66071
R213 VSS.n38 VSS.n2 5.32092
R214 VSS.n6 VSS.n17 2.6465
R215 VSS VSS.n1 1.90715
R216 VSS.n4 VSS.n3 0.88364
R217 VSS.n31 VSS.n6 1.64457
R218 VSS.n38 VSS.n15 1.27115
R219 VSS.n37 VSS.n15 1.27115
R220 VSS.n42 VSS.n41 1.27115
R221 VSS.n42 VSS.n0 1.27115
R222 VSS VSS.n7 1.00728
R223 a_92_987.n0 a_92_987.t1 4.91293
R224 a_92_987.n0 a_92_987.t0 4.89923
R225 a_92_987.n1 a_92_987.n0 2.6005
R226 a_92_987.n1 a_92_987.t3 1.41684
R227 a_92_987.t2 a_92_987.n1 1.41684
R228 EN_BAR.n8 EN_BAR.t0 50.9005
R229 EN_BAR.n5 EN_BAR.t4 40.9773
R230 EN_BAR.n2 EN_BAR.n9 32.5888
R231 EN_BAR.n5 EN_BAR.t3 19.7745
R232 EN_BAR.n9 EN_BAR.n8 16.9387
R233 EN_BAR.n7 EN_BAR.n5 11.2325
R234 EN_BAR.n8 EN_BAR.n0 11.9058
R235 EN_BAR EN_BAR.n3 7.10132
R236 EN_BAR.n3 EN_BAR.n0 3.31861
R237 EN_BAR.n9 EN_BAR.n4 3.6505
R238 EN_BAR.n7 EN_BAR.n6 2.90767
R239 EN_BAR.n2 EN_BAR.n0 0.0474974
R240 EN_BAR.n1 EN_BAR.t0 0.459182
R241 EN_BAR.n1 EN_BAR.n4 0.825727
R242 EN_BAR.n6 EN_BAR.t1 1.41684
R243 EN_BAR.n6 EN_BAR.t2 1.41684
R244 EN_BAR EN_BAR.n7 1.04415
R245 EN_BAR.n3 EN_BAR.t0 5.88322
R246 EN_BAR.n3 EN_BAR.n4 1.7588
R247 EN_BAR.n2 EN_BAR.n1 1.57306
C0 A a_181_203r# 0.10266f
C1 EN VDD 0.45659f
C2 VDD A 0.42185f
C3 EN EN_BAR 0.45732f
C4 EN Y 0.11572f
C5 VDD EN_BAR 0.6876f
C6 Y VSS 0.27605f
C7 EN VSS 1.11961f
C8 A VSS 0.89968f
C9 VDD VSS 4.52262f
C10 a_181_203r# VSS 0.21047f
C11 EN_BAR VSS 0.52837f
C12 EN_BAR.n7 VSS 0.2808f
C13 a_92_987.t3 VSS 0.10122f
C14 a_92_987.t0 VSS 0.1888f
C15 a_92_987.t1 VSS 0.17696f
C16 a_92_987.n0 VSS 0.41761f
C17 VSS.t1 VSS 0.11878f
C18 VDD.n19 VSS 0.10112f
C19 VDD.n31 VSS 0.10112f
C20 VDD.n37 VSS 0.16335f
C21 VDD.n40 VSS 0.22947f
C22 VDD.t1 VSS 0.1089f
C23 EN.n14 VSS 0.14518f
.ends
