* NGSPICE file created from gf180mcu_ocd_sc_rt12t3v3__buf_2.ext - technology: gf180mcuD

.subckt gf180mcu_ocd_sc_rt12t3v3__buf_2 A Y VDD VSS
X0 VDD.t11 A.t1 a_193_203r# VDD.t10 pfet_03v3 ad=0.3341p pd=1.805u as=0.3341p ps=1.805u w=1.285u l=0.28u
X1 Y.t5 a_193_203r# VDD.t5 VDD.t4 pfet_03v3 ad=0.3341p pd=1.805u as=0.3341p ps=1.805u w=1.285u l=0.28u
X2 Y.t2 a_193_203r# VSS.t3 VSS.t2 nfet_03v3 ad=0.3087p pd=2.01u as=2.49132p ps=12.92u w=1.02u l=0.28u
X3 VDD.t7 a_193_203r# Y.t0 VDD.t6 pfet_03v3 ad=0.5654p pd=3.45u as=0.3341p ps=1.805u w=1.285u l=0.28u
X4 Y.t3 a_193_203r# VSS.t1 VSS.t0 nfet_03v3 ad=0.3087p pd=2.01u as=2.49132p ps=12.92u w=1.02u l=0.28u
X5 Y.t4 a_193_203r# VDD.t1 VDD.t0 pfet_03v3 ad=0.3341p pd=1.805u as=0.3341p ps=1.805u w=1.285u l=0.28u
X6 a_193_203r# A.t2 VDD.t9 VDD.t8 pfet_03v3 ad=0.3341p pd=1.805u as=0.5654p ps=3.45u w=1.285u l=0.28u
X7 VDD.t3 a_193_203r# Y.t1 VDD.t2 pfet_03v3 ad=0.3341p pd=1.805u as=0.3341p ps=1.805u w=1.285u l=0.28u
X8 a_193_203r# A.t0 VSS.t5 VSS.t4 nfet_03v3 ad=0.3087p pd=2.01u as=3.73697p ps=19.385u w=1.02u l=0.28u
R0 Y.n14 Y.t2 50.9005
R1 Y.n12 Y.t3 50.9005
R2 Y.n5 Y.n15 32.5888
R3 Y.n2 Y.n13 32.5888
R4 Y.n15 Y.n14 19.8599
R5 Y.n13 Y.n12 16.9387
R6 Y.n14 Y.n3 11.9058
R7 Y.n12 Y.n0 11.9058
R8 Y Y.n7 6.68063
R9 Y Y.n6 6.3005
R10 Y.n6 Y.n3 3.31861
R11 Y.n7 Y.n0 3.31861
R12 Y.n15 Y.n8 3.6505
R13 Y.n13 Y.n9 3.6505
R14 Y Y.n11 2.96637
R15 Y Y.n10 2.96637
R16 Y.n5 Y.n3 0.0474974
R17 Y.n2 Y.n0 0.0474974
R18 Y.n4 Y.t2 0.459182
R19 Y.n1 Y.t3 0.459182
R20 Y.n4 Y.n8 0.825727
R21 Y.n1 Y.n9 0.825727
R22 Y.n10 Y.t5 1.41684
R23 Y.n10 Y.t0 1.41684
R24 Y.n11 Y.t4 1.41684
R25 Y.n11 Y.t1 1.41684
R26 Y.n6 Y.t2 5.88322
R27 Y.n7 Y.t3 5.88322
R28 Y.n7 Y.n9 1.7588
R29 Y.n6 Y.n8 1.7588
R30 Y.n5 Y.n4 1.57306
R31 Y.n2 Y.n1 1.57306
R32 A.n0 A.t1 40.1505
R33 A.n0 A.t2 19.2934
R34 A A.n0 10.0207
R35 A A.t0 7.28459
R36 VDD.n40 VDD.n39 170.816
R37 VDD.n32 VDD.t6 137.088
R38 VDD.t6 VDD.n16 137.088
R39 VDD.n38 VDD.n16 137.088
R40 VDD.n42 VDD.n41 136.919
R41 VDD.n25 VDD.n24 136.919
R42 VDD.n29 VDD.n20 136.919
R43 VDD.n42 VDD.t8 117.359
R44 VDD.n30 VDD.t2 117.359
R45 VDD.n26 VDD.t10 97.8
R46 VDD.n26 VDD.t0 97.8
R47 VDD.n32 VDD.n31 90.5758
R48 VDD.n31 VDD.n30 46.4553
R49 VDD.t10 VDD.n25 39.1203
R50 VDD.t0 VDD.n20 39.1203
R51 VDD.n31 VDD.t4 31.7853
R52 VDD.n24 VDD.t8 19.5604
R53 VDD.t2 VDD.n29 19.5604
R54 VDD.n36 VDD.n35 9.8005
R55 VDD.n44 VDD.n43 9.8005
R56 VDD.n43 VDD.n7 2.75725
R57 VDD.n23 VDD.n10 9.8005
R58 VDD.n27 VDD.n23 9.8005
R59 VDD.n5 VDD.n4 2.75725
R60 VDD.n28 VDD.n4 9.8005
R61 VDD.n6 VDD.n19 2.75725
R62 VDD.n33 VDD.n19 9.8005
R63 VDD.n33 VDD.n18 9.8005
R64 VDD.n8 VDD.n18 2.75725
R65 VDD.n37 VDD.n34 9.8005
R66 VDD.n13 VDD.n12 9.8005
R67 VDD.n2 VDD.n9 4.93411
R68 VDD.n3 VDD.n17 4.93411
R69 VDD VDD.n44 6.3005
R70 VDD.n43 VDD.n42 6.3005
R71 VDD.n7 VDD 1.77287
R72 VDD.n24 VDD.n10 6.3005
R73 VDD.n7 VDD.n10 2.75725
R74 VDD.n25 VDD.n23 6.3005
R75 VDD.n23 VDD 6.3005
R76 VDD.n27 VDD.n26 6.3005
R77 VDD.n5 VDD.n27 2.75725
R78 VDD.n4 VDD.n20 6.3005
R79 VDD VDD.n5 1.77287
R80 VDD.n29 VDD.n28 6.3005
R81 VDD.n28 VDD.n6 2.75725
R82 VDD.n30 VDD.n19 6.3005
R83 VDD.n6 VDD 1.77287
R84 VDD.n33 VDD.n32 6.3005
R85 VDD VDD.n33 6.3005
R86 VDD.t6 VDD.n18 6.3005
R87 VDD VDD.n8 1.77287
R88 VDD.n34 VDD.n16 6.3005
R89 VDD.n34 VDD.n8 2.75725
R90 VDD.n38 VDD.n37 6.3005
R91 VDD.n37 VDD.n3 2.17736
R92 VDD.n39 VDD.n38 6.3005
R93 VDD.n35 VDD 6.3005
R94 VDD VDD.n36 6.3005
R95 VDD.n3 VDD 2.06282
R96 VDD.n2 VDD.n1 1.77287
R97 VDD.n1 VDD.n13 6.3005
R98 VDD.n41 VDD.n12 6.3005
R99 VDD.n41 VDD.n40 6.3005
R100 VDD.n15 VDD.n0 5.4873
R101 VDD VDD.t9 4.32793
R102 VDD VDD.t7 4.32597
R103 VDD VDD.n21 2.91159
R104 VDD VDD.n22 2.91159
R105 VDD.n39 VDD.n0 2.82549
R106 VDD.n40 VDD.n14 2.82549
R107 VDD.n35 VDD.n15 2.75725
R108 VDD.n36 VDD.n17 2.75725
R109 VDD.n13 VDD.n11 2.75725
R110 VDD.n2 VDD.n11 5.514
R111 VDD.n14 VDD.n12 2.73055
R112 VDD.n44 VDD.n9 2.17736
R113 VDD.n41 VDD.n9 2.06282
R114 VDD VDD.n0 2.03587
R115 VDD.n14 VDD.n1 2.03587
R116 VDD VDD.n1 2.0045
R117 VDD.n38 VDD.n15 1.77287
R118 VDD.n38 VDD.n17 1.77287
R119 VDD.n41 VDD.n11 1.77287
R120 VDD.n21 VDD.t3 1.41684
R121 VDD.n21 VDD.t5 1.41684
R122 VDD.n22 VDD.t11 1.41684
R123 VDD.n22 VDD.t1 1.41684
R124 VSS.n43 VSS.n42 514.125
R125 VSS.n26 VSS.n25 514.125
R126 VSS.n26 VSS.n24 514.125
R127 VSS.n30 VSS.n29 514.125
R128 VSS.n30 VSS.n21 514.125
R129 VSS.n34 VSS.n33 514.125
R130 VSS.n35 VSS.n34 514.125
R131 VSS.n35 VSS.n18 514.125
R132 VSS.n24 VSS.t0 472.812
R133 VSS.n21 VSS.t2 403.955
R134 VSS.n43 VSS.t4 316.738
R135 VSS.n40 VSS.n39 202.63
R136 VSS.n25 VSS.t4 197.387
R137 VSS.n33 VSS.t2 110.169
R138 VSS.n29 VSS.t0 41.3141
R139 VSS.n44 VSS.n17 10.8894
R140 VSS.n36 VSS.n12 10.7402
R141 VSS.n27 VSS.n22 10.4384
R142 VSS.n15 VSS.n22 2.57652
R143 VSS.n36 VSS.n14 2.56499
R144 VSS.n32 VSS.n13 2.54404
R145 VSS.n31 VSS.n16 9.94306
R146 VSS.n44 VSS.n8 9.76841
R147 VSS.n11 VSS.n17 7.38939
R148 VSS.n10 VSS.n12 2.14419
R149 VSS.n27 VSS.n7 2.35671
R150 VSS VSS.n40 5.41963
R151 VSS.n39 VSS 5.41963
R152 VSS.n28 VSS.n6 5.39809
R153 VSS.n4 VSS.n3 5.31375
R154 VSS.n44 VSS.n43 5.2005
R155 VSS VSS.n44 5.2005
R156 VSS.n42 VSS.n17 5.2005
R157 VSS.n17 VSS 5.2005
R158 VSS.n27 VSS.n26 5.2005
R159 VSS.n25 VSS.n8 5.2005
R160 VSS.n8 VSS 5.2005
R161 VSS.n24 VSS.n22 5.2005
R162 VSS VSS.n15 1.31324
R163 VSS.n31 VSS.n30 5.2005
R164 VSS VSS.n5 1.32216
R165 VSS.n29 VSS.n28 5.2005
R166 VSS.n28 VSS.n15 2.57652
R167 VSS.n21 VSS.n16 5.2005
R168 VSS.n13 VSS.n16 2.54404
R169 VSS.n34 VSS.n3 5.2005
R170 VSS.n14 VSS.n3 2.56499
R171 VSS.n33 VSS.n32 5.2005
R172 VSS.n13 VSS 1.32948
R173 VSS.n12 VSS.n18 5.2005
R174 VSS VSS.n10 1.5294
R175 VSS.n36 VSS.n35 5.2005
R176 VSS VSS.n14 1.319
R177 VSS.n2 VSS 1.27115
R178 VSS.n37 VSS.n2 5.32092
R179 VSS VSS.n11 5.2005
R180 VSS VSS.n1 1.27115
R181 VSS.n4 VSS.t3 4.4105
R182 VSS.n6 VSS.t1 4.4105
R183 VSS.n9 VSS.t5 4.4105
R184 VSS.n32 VSS.n4 4.13303
R185 VSS.n31 VSS.n5 1.69888
R186 VSS.n9 VSS.n7 1.42802
R187 VSS.n6 VSS.n5 1.02952
R188 VSS VSS.n4 3.1505
R189 VSS.n9 VSS.n23 2.7725
R190 VSS.n40 VSS.n0 2.66071
R191 VSS.n39 VSS.n38 2.66071
R192 VSS.n41 VSS.n11 2.66071
R193 VSS.n41 VSS.n1 5.32092
R194 VSS.n1 VSS.n0 5.32092
R195 VSS.n37 VSS.n10 4.8044
R196 VSS.n6 VSS.n20 2.9615
R197 VSS.n4 VSS.n19 2.9615
R198 VSS.n9 VSS.n8 2.71962
R199 VSS.n38 VSS.n2 5.32092
R200 VSS VSS.n7 2.02996
R201 VSS.n38 VSS.n18 1.27115
R202 VSS.n37 VSS.n18 1.27115
R203 VSS.n42 VSS.n41 1.27115
R204 VSS.n42 VSS.n0 1.27115
C0 A VDD 0.4042f
C1 Y a_193_203r# 0.46266f
C2 Y VDD 0.46914f
C3 a_193_203r# VDD 0.88016f
C4 a_193_203r# A 0.30175f
C5 Y VSS 0.60088f
C6 A VSS 0.84155f
C7 VDD VSS 4.15426f
C8 a_193_203r# VSS 0.11869f
C9 VSS.t5 VSS 0.11869f
C10 VDD.t5 VSS 0.42871f
C11 VDD.n38 VSS 0.14282f
C12 VDD.n41 VSS 0.14299f
C13 Y.t5 VSS 0.44472f
.ends
