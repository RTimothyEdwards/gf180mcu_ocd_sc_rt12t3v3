* NGSPICE file created from gf180mcu_ocd_sc_rt12t3v3__buf_2.ext - technology: gf180mcuD

.subckt gf180mcu_ocd_sc_rt12t3v3__buf_2 A Y VDD VSS
X0 VDD.t11 A.t1 a_193_203r# VDD.t10 pfet_03v3 ad=0.3341p pd=1.805u as=0.3341p ps=1.805u w=1.285u l=0.28u
X1 Y.t3 a_193_203r# VDD.t5 VDD.t4 pfet_03v3 ad=0.3341p pd=1.805u as=0.3341p ps=1.805u w=1.285u l=0.28u
X2 Y.t0 a_193_203r# VSS.t3 VSS.t2 nfet_03v3 ad=0.3087p pd=2.01u as=2.49132p ps=12.92u w=1.02u l=0.28u
X3 VDD.t7 a_193_203r# Y.t5 VDD.t6 pfet_03v3 ad=0.5654p pd=3.45u as=0.3341p ps=1.805u w=1.285u l=0.28u
X4 Y.t2 a_193_203r# VSS.t1 VSS.t0 nfet_03v3 ad=0.3087p pd=2.01u as=2.49132p ps=12.92u w=1.02u l=0.28u
X5 Y.t1 a_193_203r# VDD.t1 VDD.t0 pfet_03v3 ad=0.3341p pd=1.805u as=0.3341p ps=1.805u w=1.285u l=0.28u
X6 a_193_203r# A.t2 VDD.t9 VDD.t8 pfet_03v3 ad=0.3341p pd=1.805u as=0.5654p ps=3.45u w=1.285u l=0.28u
X7 VDD.t3 a_193_203r# Y.t4 VDD.t2 pfet_03v3 ad=0.3341p pd=1.805u as=0.3341p ps=1.805u w=1.285u l=0.28u
X8 a_193_203r# A.t0 VSS.t5 VSS.t4 nfet_03v3 ad=0.3087p pd=2.01u as=3.73697p ps=19.385u w=1.02u l=0.28u
R0 Y.n4 Y.n0 3.37947
R1 Y Y.n0 6.88006
R2 Y.t0 Y.n0 0.645433
R3 Y.t2 Y.n3 3.32853
R4 Y Y.n2 2.96637
R5 Y Y.n1 2.96637
R6 Y.n1 Y.t3 1.41684
R7 Y.n1 Y.t5 1.41684
R8 Y.n2 Y.t1 1.41684
R9 Y.n2 Y.t4 1.41684
R10 Y Y.t2 7.38308
R11 A.n0 A.t1 40.1505
R12 A.n0 A.t2 19.2934
R13 A A.n0 10.0207
R14 A A.t0 6.85756
R15 VDD.n40 VDD.n39 170.816
R16 VDD.n32 VDD.t6 137.088
R17 VDD.t6 VDD.n16 137.088
R18 VDD.n38 VDD.n16 137.088
R19 VDD.n42 VDD.n41 136.919
R20 VDD.n25 VDD.n24 136.919
R21 VDD.n29 VDD.n20 136.919
R22 VDD.n42 VDD.t8 117.359
R23 VDD.n30 VDD.t2 117.359
R24 VDD.n26 VDD.t10 97.8
R25 VDD.n26 VDD.t0 97.8
R26 VDD.n32 VDD.n31 90.5758
R27 VDD.n31 VDD.n30 46.4553
R28 VDD.t10 VDD.n25 39.1203
R29 VDD.t0 VDD.n20 39.1203
R30 VDD.n31 VDD.t4 31.7853
R31 VDD.n24 VDD.t8 19.5604
R32 VDD.t2 VDD.n29 19.5604
R33 VDD.n36 VDD.n35 9.8005
R34 VDD.n44 VDD.n43 9.8005
R35 VDD.n43 VDD.n7 2.75725
R36 VDD.n23 VDD.n10 9.8005
R37 VDD.n27 VDD.n23 9.8005
R38 VDD.n5 VDD.n4 2.75725
R39 VDD.n28 VDD.n4 9.8005
R40 VDD.n6 VDD.n19 2.75725
R41 VDD.n33 VDD.n19 9.8005
R42 VDD.n33 VDD.n18 9.8005
R43 VDD.n8 VDD.n18 2.75725
R44 VDD.n37 VDD.n34 9.8005
R45 VDD.n13 VDD.n12 9.8005
R46 VDD.n2 VDD.n9 4.93411
R47 VDD.n3 VDD.n17 4.93411
R48 VDD VDD.n44 6.3005
R49 VDD.n43 VDD.n42 6.3005
R50 VDD.n7 VDD 1.77287
R51 VDD.n24 VDD.n10 6.3005
R52 VDD.n7 VDD.n10 2.75725
R53 VDD.n25 VDD.n23 6.3005
R54 VDD.n23 VDD 6.3005
R55 VDD.n27 VDD.n26 6.3005
R56 VDD.n5 VDD.n27 2.75725
R57 VDD.n4 VDD.n20 6.3005
R58 VDD VDD.n5 1.77287
R59 VDD.n29 VDD.n28 6.3005
R60 VDD.n28 VDD.n6 2.75725
R61 VDD.n30 VDD.n19 6.3005
R62 VDD.n6 VDD 1.77287
R63 VDD.n33 VDD.n32 6.3005
R64 VDD VDD.n33 6.3005
R65 VDD.t6 VDD.n18 6.3005
R66 VDD VDD.n8 1.77287
R67 VDD.n34 VDD.n16 6.3005
R68 VDD.n34 VDD.n8 2.75725
R69 VDD.n38 VDD.n37 6.3005
R70 VDD.n37 VDD.n3 2.17736
R71 VDD.n39 VDD.n38 6.3005
R72 VDD.n35 VDD 6.3005
R73 VDD VDD.n36 6.3005
R74 VDD.n3 VDD 2.06282
R75 VDD.n2 VDD.n1 1.77287
R76 VDD.n1 VDD.n13 6.3005
R77 VDD.n41 VDD.n12 6.3005
R78 VDD.n41 VDD.n40 6.3005
R79 VDD.n15 VDD.n0 5.4873
R80 VDD VDD.t9 4.32793
R81 VDD VDD.t7 4.32597
R82 VDD VDD.n21 2.91159
R83 VDD VDD.n22 2.91159
R84 VDD.n39 VDD.n0 2.82549
R85 VDD.n40 VDD.n14 2.82549
R86 VDD.n35 VDD.n15 2.75725
R87 VDD.n36 VDD.n17 2.75725
R88 VDD.n13 VDD.n11 2.75725
R89 VDD.n2 VDD.n11 5.514
R90 VDD.n14 VDD.n12 2.73055
R91 VDD.n44 VDD.n9 2.17736
R92 VDD.n41 VDD.n9 2.06282
R93 VDD VDD.n0 2.03587
R94 VDD.n14 VDD.n1 2.03587
R95 VDD VDD.n1 2.0045
R96 VDD.n38 VDD.n15 1.77287
R97 VDD.n38 VDD.n17 1.77287
R98 VDD.n41 VDD.n11 1.77287
R99 VDD.n21 VDD.t3 1.41684
R100 VDD.n21 VDD.t5 1.41684
R101 VDD.n22 VDD.t11 1.41684
R102 VDD.n22 VDD.t1 1.41684
R103 VSS.n43 VSS.n42 514.125
R104 VSS.n26 VSS.n25 514.125
R105 VSS.n26 VSS.n24 514.125
R106 VSS.n30 VSS.n29 514.125
R107 VSS.n30 VSS.n21 514.125
R108 VSS.n34 VSS.n33 514.125
R109 VSS.n35 VSS.n34 514.125
R110 VSS.n35 VSS.n18 514.125
R111 VSS.n24 VSS.t0 472.812
R112 VSS.n21 VSS.t2 403.955
R113 VSS.n43 VSS.t4 316.738
R114 VSS.n40 VSS.n39 202.63
R115 VSS.n25 VSS.t4 197.387
R116 VSS.n33 VSS.t2 110.169
R117 VSS.n29 VSS.t0 41.3141
R118 VSS.n44 VSS.n17 10.8894
R119 VSS.n36 VSS.n12 10.7402
R120 VSS.n27 VSS.n22 10.4384
R121 VSS.n15 VSS.n22 2.57652
R122 VSS.n36 VSS.n14 2.56499
R123 VSS.n32 VSS.n13 2.54404
R124 VSS.n31 VSS.n16 9.94306
R125 VSS.n44 VSS.n8 9.76841
R126 VSS.n11 VSS.n17 7.38939
R127 VSS.n10 VSS.n12 2.14419
R128 VSS.n27 VSS.n7 2.35671
R129 VSS VSS.n40 5.41963
R130 VSS.n39 VSS 5.41963
R131 VSS.n28 VSS.n5 5.39809
R132 VSS.n4 VSS.n3 5.31375
R133 VSS.n44 VSS.n43 5.2005
R134 VSS VSS.n44 5.2005
R135 VSS.n42 VSS.n17 5.2005
R136 VSS.n17 VSS 5.2005
R137 VSS.n27 VSS.n26 5.2005
R138 VSS.n25 VSS.n8 5.2005
R139 VSS.n8 VSS 5.2005
R140 VSS.n24 VSS.n22 5.2005
R141 VSS VSS.n15 1.31324
R142 VSS.n31 VSS.n30 5.2005
R143 VSS.n6 VSS.n31 1.67338
R144 VSS.n29 VSS.n28 5.2005
R145 VSS.n28 VSS.n15 2.57652
R146 VSS.n21 VSS.n16 5.2005
R147 VSS.n13 VSS.n16 2.54404
R148 VSS.n34 VSS.n3 5.2005
R149 VSS.n14 VSS.n3 2.56499
R150 VSS.n33 VSS.n32 5.2005
R151 VSS.n13 VSS 1.32948
R152 VSS.n12 VSS.n18 5.2005
R153 VSS VSS.n10 1.5294
R154 VSS.n36 VSS.n35 5.2005
R155 VSS VSS.n14 1.319
R156 VSS.n2 VSS 1.27115
R157 VSS.n37 VSS.n2 5.32092
R158 VSS VSS.n11 5.2005
R159 VSS VSS.n1 1.27115
R160 VSS.n4 VSS.n19 4.5995
R161 VSS.n5 VSS.n20 4.5995
R162 VSS.n9 VSS.n23 4.5995
R163 VSS.n4 VSS.t3 4.4105
R164 VSS.n5 VSS.t1 4.4105
R165 VSS.n9 VSS.t5 4.4105
R166 VSS.n32 VSS.n4 4.13303
R167 VSS.n6 VSS.n5 1.07486
R168 VSS.n9 VSS.n7 1.42802
R169 VSS.n40 VSS.n0 2.66071
R170 VSS.n39 VSS.n38 2.66071
R171 VSS.n41 VSS.n11 2.66071
R172 VSS.n41 VSS.n1 5.32092
R173 VSS.n1 VSS.n0 5.32092
R174 VSS.n37 VSS.n10 4.8044
R175 VSS VSS.n4 3.3395
R176 VSS.n6 VSS 1.3804
R177 VSS.n9 VSS.n8 2.71962
R178 VSS.n38 VSS.n2 5.32092
R179 VSS VSS.n7 2.02996
R180 VSS.n38 VSS.n18 1.27115
R181 VSS.n37 VSS.n18 1.27115
R182 VSS.n42 VSS.n41 1.27115
R183 VSS.n42 VSS.n0 1.27115
C0 Y a_193_203r# 0.66591f
C1 a_193_203r# A 0.49042f
C2 Y VDD 0.7539f
C3 A VDD 0.44487f
C4 a_193_203r# VDD 1.022f
C5 Y VSS 0.94995f
C6 A VSS 0.97781f
C7 VDD VSS 4.22708f
C8 a_193_203r# VSS 0.88045f
C9 VDD.n16 VSS 0.11381f
C10 VDD.t6 VSS 0.11381f
C11 VDD.n38 VSS 0.18088f
C12 VDD.n41 VSS 0.1811f
C13 VDD.n42 VSS 0.10581f
C14 A.t0 VSS 0.35165f
C15 Y.t2 VSS 0.128f
C16 Y.n3 VSS 0.13288f
C17 Y.n4 VSS 0.14252f
.ends
