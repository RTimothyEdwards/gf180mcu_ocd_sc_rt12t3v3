* NGSPICE file created from gf180mcu_ocd_sc_rt12t3v3__and2_1.ext - technology: gf180mcuD

.subckt gf180mcu_ocd_sc_rt12t3v3__and2_1 A B Y VDD VSS
X0 a_236_987.t0 A.t0 a_193_203r# VSS.t2 nfet_03v3 ad=0.3087p pd=2.015u as=0.52065p ps=3.23u w=1.02u l=0.28u
X1 VDD.t11 B.t1 a_236_987.t4 VDD.t10 pfet_03v3 ad=0.3341p pd=1.805u as=0.3341p ps=1.805u w=1.285u l=0.28u
X2 Y.t2 a_236_987.t7 VDD.t3 VDD.t2 pfet_03v3 ad=0.3341p pd=1.805u as=0.3341p ps=1.805u w=1.285u l=0.28u
X3 VDD.t1 a_236_987.t6 Y.t1 VDD.t0 pfet_03v3 ad=0.5654p pd=3.45u as=0.3341p ps=1.805u w=1.285u l=0.28u
X4 a_236_987.t1 A.t2 VDD.t7 VDD.t6 pfet_03v3 ad=0.3341p pd=1.805u as=0.3341p ps=1.805u w=1.285u l=0.28u
X5 a_236_987.t3 B.t2 VDD.t9 VDD.t8 pfet_03v3 ad=0.3341p pd=1.805u as=0.5654p ps=3.45u w=1.285u l=0.28u
X6 VDD.t5 A.t1 a_236_987.t2 VDD.t4 pfet_03v3 ad=0.3341p pd=1.805u as=0.3341p ps=1.805u w=1.285u l=0.28u
X7 a_193_203r# B.t0 VSS.t4 VSS.t3 nfet_03v3 ad=0.3087p pd=2.01u as=3.40955p ps=18.84u w=1.02u l=0.28u
X8 Y.t0 a_236_987.t5 VSS.t1 VSS.t0 nfet_03v3 ad=0.3087p pd=2.01u as=3.40955p ps=18.84u w=1.02u l=0.28u
R0 Y.t0 Y.n1 3.32853
R1 Y Y.n0 2.98579
R2 Y.n0 Y.t2 1.41684
R3 Y.n0 Y.t1 1.41684
R4 Y Y.t0 7.10006
R5 A.n0 A.t1 40.1505
R6 A.n0 A.t2 19.2934
R7 A A.n0 9.82344
R8 A A.t0 11.2996
R9 B.n0 B.t1 40.1505
R10 B.n0 B.t2 19.2934
R11 B B.n0 10.0207
R12 B B.t0 8.39395
R13 VDD.n39 VDD.n38 170.816
R14 VDD.n41 VDD.n40 137.088
R15 VDD.n25 VDD.n24 137.088
R16 VDD.n29 VDD.n20 137.088
R17 VDD.n31 VDD.t0 137.088
R18 VDD.t0 VDD.n16 137.088
R19 VDD.n37 VDD.n16 137.088
R20 VDD.n41 VDD.t8 117.504
R21 VDD.n30 VDD.t4 117.504
R22 VDD.n26 VDD.t10 97.9197
R23 VDD.n26 VDD.t6 97.9197
R24 VDD.t2 VDD.n30 78.3359
R25 VDD.n31 VDD.t2 58.752
R26 VDD.t10 VDD.n25 39.1682
R27 VDD.t6 VDD.n20 39.1682
R28 VDD.n24 VDD.t8 19.5843
R29 VDD.t4 VDD.n29 19.5843
R30 VDD.n35 VDD.n34 9.8005
R31 VDD.n43 VDD.n42 9.8005
R32 VDD.n42 VDD.n7 2.75725
R33 VDD.n23 VDD.n10 9.8005
R34 VDD.n27 VDD.n23 9.8005
R35 VDD.n5 VDD.n4 2.75725
R36 VDD.n28 VDD.n4 9.8005
R37 VDD.n6 VDD.n19 2.75725
R38 VDD.n32 VDD.n19 9.8005
R39 VDD.n32 VDD.n18 9.8005
R40 VDD.n8 VDD.n18 2.75725
R41 VDD.n36 VDD.n33 9.8005
R42 VDD.n13 VDD.n12 9.8005
R43 VDD.n2 VDD.n9 4.93411
R44 VDD.n3 VDD.n17 4.93411
R45 VDD VDD.n43 6.3005
R46 VDD.n42 VDD.n41 6.3005
R47 VDD.n7 VDD 1.77287
R48 VDD.n24 VDD.n10 6.3005
R49 VDD.n7 VDD.n10 2.75725
R50 VDD.n25 VDD.n23 6.3005
R51 VDD.n23 VDD 6.3005
R52 VDD.n27 VDD.n26 6.3005
R53 VDD.n5 VDD.n27 2.75725
R54 VDD.n4 VDD.n20 6.3005
R55 VDD VDD.n5 1.77287
R56 VDD.n29 VDD.n28 6.3005
R57 VDD.n28 VDD.n6 2.75725
R58 VDD.n30 VDD.n19 6.3005
R59 VDD.n6 VDD 1.77287
R60 VDD.n32 VDD.n31 6.3005
R61 VDD VDD.n32 6.3005
R62 VDD.t0 VDD.n18 6.3005
R63 VDD VDD.n8 1.77287
R64 VDD.n33 VDD.n16 6.3005
R65 VDD.n33 VDD.n8 2.75725
R66 VDD.n37 VDD.n36 6.3005
R67 VDD.n36 VDD.n3 2.17736
R68 VDD.n38 VDD.n37 6.3005
R69 VDD.n34 VDD 6.3005
R70 VDD VDD.n35 6.3005
R71 VDD.n3 VDD 2.06282
R72 VDD.n2 VDD.n1 1.77287
R73 VDD.n1 VDD.n13 6.3005
R74 VDD.n40 VDD.n12 6.3005
R75 VDD.n40 VDD.n39 6.3005
R76 VDD.n15 VDD.n0 5.4873
R77 VDD VDD.n22 5.42159
R78 VDD VDD.t9 4.32793
R79 VDD VDD.t1 4.32597
R80 VDD VDD.n21 2.91159
R81 VDD.n38 VDD.n0 2.82549
R82 VDD.n39 VDD.n14 2.82549
R83 VDD.n34 VDD.n15 2.75725
R84 VDD.n35 VDD.n17 2.75725
R85 VDD.n13 VDD.n11 2.75725
R86 VDD.n2 VDD.n11 5.514
R87 VDD.n14 VDD.n12 2.73055
R88 VDD.n43 VDD.n9 2.17736
R89 VDD.n40 VDD.n9 2.06282
R90 VDD VDD.n0 2.03587
R91 VDD.n14 VDD.n1 2.03587
R92 VDD VDD.n1 2.0045
R93 VDD.n37 VDD.n15 1.77287
R94 VDD.n37 VDD.n17 1.77287
R95 VDD.n40 VDD.n11 1.77287
R96 VDD.n21 VDD.t5 1.41684
R97 VDD.n21 VDD.t3 1.41684
R98 VDD.n22 VDD.t11 1.41684
R99 VDD.n22 VDD.t7 1.41684
R100 VSS.n40 VSS.n39 513.399
R101 VSS.n25 VSS.n22 513.399
R102 VSS.n26 VSS.n25 513.399
R103 VSS.n27 VSS.n26 513.399
R104 VSS.n30 VSS.n20 513.399
R105 VSS.n31 VSS.n30 513.399
R106 VSS.n32 VSS.n19 513.399
R107 VSS.n19 VSS.n16 513.399
R108 VSS.t2 VSS.n20 467.56
R109 VSS.n40 VSS.t3 316.291
R110 VSS.n32 VSS.t0 316.291
R111 VSS.n37 VSS.n36 202.63
R112 VSS.n22 VSS.t3 197.109
R113 VSS.t0 VSS.n31 197.109
R114 VSS.n27 VSS.t2 45.8397
R115 VSS.n28 VSS.n21 10.8894
R116 VSS.n11 VSS.n10 2.66071
R117 VSS.n29 VSS.n10 10.8894
R118 VSS.n41 VSS.n15 10.8894
R119 VSS.n12 VSS.n14 2.65917
R120 VSS.n5 VSS.n13 2.64679
R121 VSS.n24 VSS.n21 10.4384
R122 VSS.n41 VSS.n6 9.76841
R123 VSS.n1 VSS.n14 9.44628
R124 VSS.n1 VSS.n5 9.10893
R125 VSS.n9 VSS.n15 7.38939
R126 VSS.n33 VSS.n17 7.38939
R127 VSS.n24 VSS.n8 2.35671
R128 VSS VSS.n37 5.41963
R129 VSS.n36 VSS.n0 5.41963
R130 VSS.n41 VSS.n40 5.2005
R131 VSS VSS.n41 5.2005
R132 VSS.n39 VSS.n15 5.2005
R133 VSS.n15 VSS 5.2005
R134 VSS.n25 VSS.n24 5.2005
R135 VSS.n22 VSS.n6 5.2005
R136 VSS.n6 VSS 5.2005
R137 VSS.n31 VSS.n14 5.2005
R138 VSS VSS.n12 1.27192
R139 VSS.n30 VSS.n29 5.2005
R140 VSS.n29 VSS.n12 2.65917
R141 VSS.n10 VSS.n20 5.2005
R142 VSS VSS.n11 1.27115
R143 VSS.n28 VSS.n27 5.2005
R144 VSS.n11 VSS.n28 2.66071
R145 VSS.n26 VSS.n21 5.2005
R146 VSS.n21 VSS 5.2005
R147 VSS.n1 VSS.n32 5.2005
R148 VSS.n17 VSS.n16 5.2005
R149 VSS.n13 VSS.n17 2.64679
R150 VSS.n19 VSS.n5 5.2005
R151 VSS VSS.n13 1.2781
R152 VSS.n4 VSS.n0 1.27115
R153 VSS.n34 VSS.n4 5.32092
R154 VSS.n33 VSS 5.2005
R155 VSS VSS.n9 5.2005
R156 VSS VSS.n3 1.27115
R157 VSS.n1 VSS.n18 4.5995
R158 VSS.n7 VSS.n23 4.5995
R159 VSS.n1 VSS.t1 4.4105
R160 VSS.n7 VSS.t4 4.4105
R161 VSS.n8 VSS.n7 1.42802
R162 VSS.n7 VSS.n6 2.71962
R163 VSS.n37 VSS.n2 2.66071
R164 VSS.n36 VSS.n35 2.66071
R165 VSS.n38 VSS.n9 2.66071
R166 VSS.n38 VSS.n3 5.32092
R167 VSS.n3 VSS.n2 5.32092
R168 VSS.n34 VSS.n33 2.66071
R169 VSS.n35 VSS.n4 5.32092
R170 VSS.n1 VSS 2.34249
R171 VSS.n35 VSS.n16 1.27115
R172 VSS.n34 VSS.n16 1.27115
R173 VSS.n39 VSS.n38 1.27115
R174 VSS.n39 VSS.n2 1.27115
R175 VSS VSS.n0 1.19582
R176 VSS.n8 VSS 1.074
R177 a_236_987.n2 a_236_987.t6 40.1505
R178 a_236_987.n2 a_236_987.t7 19.2934
R179 a_236_987.n1 a_236_987.n2 9.56479
R180 a_236_987.n0 a_236_987.t5 7.76514
R181 a_236_987.n0 a_236_987.t0 7.67676
R182 a_236_987.n1 a_236_987.n3 3.3518
R183 a_236_987.n4 a_236_987.n1 2.72963
R184 a_236_987.n1 a_236_987.n0 1.4405
R185 a_236_987.t1 a_236_987.n4 1.41684
R186 a_236_987.n4 a_236_987.t2 1.41684
R187 a_236_987.n3 a_236_987.t3 1.41684
R188 a_236_987.n3 a_236_987.t4 1.41684
C0 VDD A 0.34663f
C1 B a_193_203r# 0.12267f
C2 VDD Y 0.53282f
C3 VDD B 0.44566f
C4 B A 0.13616f
C5 Y VSS 0.80934f
C6 A VSS 0.94854f
C7 B VSS 0.90716f
C8 VDD VSS 4.23681f
C9 a_193_203r# VSS 0.15767f
C10 a_236_987.t0 VSS 0.34675f
C11 a_236_987.n0 VSS 0.4464f
C12 a_236_987.n1 VSS 0.36893f
C13 a_236_987.t5 VSS 0.44945f
C14 a_236_987.n2 VSS 0.10069f
C15 a_236_987.n3 VSS 0.11333f
C16 VDD.n16 VSS 0.11948f
C17 VDD.t0 VSS 0.11948f
C18 VDD.n37 VSS 0.18988f
C19 VDD.n40 VSS 0.18988f
C20 VDD.n41 VSS 0.11094f
C21 B.t0 VSS 0.29992f
C22 A.t0 VSS 0.4784f
C23 A.n0 VSS 0.1029f
C24 Y.t0 VSS 0.15565f
C25 Y.n1 VSS 0.16652f
.ends
