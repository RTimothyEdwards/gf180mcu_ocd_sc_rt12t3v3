* NGSPICE file created from gf180mcu_ocd_sc_rt12t3v3__tieh.ext - technology: gf180mcuD

.subckt gf180mcu_ocd_sc_rt12t3v3__tieh Y VDD VSS
X0 VDD.t3 a_93_147# Y.t0 VDD.t2 pfet_03v3 ad=2.7424p pd=12.83u as=0.3341p ps=1.805u w=1.285u l=0.28u
X1 Y.t1 a_93_147# VDD.t1 VDD.t0 pfet_03v3 ad=0.3341p pd=1.805u as=2.7424p ps=12.83u w=1.285u l=0.28u
X2 a_93_147# a_93_147# VSS.t1 VSS.t0 nfet_03v3 ad=0.3087p pd=2.01u as=4.22095p ps=23.13u w=1.02u l=0.28u
R0 Y Y.n0 2.98876
R1 Y.n0 Y.t0 1.41684
R2 Y.n0 Y.t1 1.41684
R3 VDD.n28 VDD.n14 137.088
R4 VDD.n24 VDD.n23 137.088
R5 VDD.n22 VDD.n0 137.088
R6 VDD.t0 VDD.n14 117.504
R7 VDD.t2 VDD.n22 97.9197
R8 VDD.n19 VDD.n15 74.5982
R9 VDD.n23 VDD.t2 39.1682
R10 VDD.n24 VDD.t0 19.5843
R11 VDD.n29 VDD.n13 9.8005
R12 VDD.n25 VDD.n11 2.75725
R13 VDD.n25 VDD.n17 9.8005
R14 VDD.n21 VDD.n17 9.8005
R15 VDD.n10 VDD.n20 4.85219
R16 VDD.n8 VDD.n18 5.40705
R17 VDD VDD.n19 6.51963
R18 VDD.n29 VDD.n28 6.3005
R19 VDD VDD.n29 6.3005
R20 VDD.n14 VDD.n13 6.3005
R21 VDD.n13 VDD.n11 2.75725
R22 VDD.n25 VDD.n24 6.3005
R23 VDD VDD.n11 1.77287
R24 VDD.n23 VDD.n17 6.3005
R25 VDD.n17 VDD 6.3005
R26 VDD.n22 VDD.n21 6.3005
R27 VDD.n21 VDD.n10 2.75725
R28 VDD VDD.n10 1.77287
R29 VDD.n12 VDD 6.3005
R30 VDD.n6 VDD.n7 1.85802
R31 VDD.n9 VDD.n7 2.22249
R32 VDD.n28 VDD.n15 6.3005
R33 VDD VDD.n8 1.82635
R34 VDD.n1 VDD.n0 2.13272
R35 VDD.n4 VDD.n1 2.03756
R36 VDD.n4 VDD.n2 2.101
R37 VDD VDD.n2 2.101
R38 VDD.n20 VDD.n2 4.19594
R39 VDD.n29 VDD.n12 6.19113
R40 VDD.n1 VDD.n8 4.68735
R41 VDD.n26 VDD.n16 5.35538
R42 VDD.n16 VDD.n7 4.48286
R43 VDD.n5 VDD 2.91159
R44 VDD VDD.n3 2.90963
R45 VDD.n26 VDD.n15 2.82549
R46 VDD.n19 VDD.n18 2.75725
R47 VDD.n28 VDD.n27 2.1923
R48 VDD.n20 VDD.n0 2.10378
R49 VDD.n9 VDD.n26 2.03587
R50 VDD.n27 VDD.n12 1.91839
R51 VDD.n27 VDD.n6 1.91839
R52 VDD.n28 VDD.n16 1.83883
R53 VDD.n18 VDD.n0 1.77287
R54 VDD.n9 VDD 1.71963
R55 VDD.n5 VDD.t1 1.41684
R56 VDD.n3 VDD.t3 1.41684
R57 VDD.n4 VDD.n3 1.26229
R58 VDD.n6 VDD.n5 1.22714
R59 VSS.n15 VSS.n12 452.993
R60 VSS.n23 VSS.n8 452.736
R61 VSS.n18 VSS.n12 452.736
R62 VSS.t0 VSS.n8 254.665
R63 VSS.n18 VSS.t0 198.072
R64 VSS.n17 VSS.n5 10.8894
R65 VSS.n17 VSS.n13 10.8894
R66 VSS.n1 VSS.n19 2.66071
R67 VSS.n19 VSS.n11 10.8894
R68 VSS.n22 VSS.n6 10.4384
R69 VSS.n25 VSS.n2 9.76841
R70 VSS.n16 VSS.n15 7.43544
R71 VSS.n15 VSS.n14 7.43544
R72 VSS.n5 VSS.n7 7.38939
R73 VSS.n21 VSS.n20 7.38939
R74 VSS.n22 VSS.n4 2.35671
R75 VSS VSS.n25 5.2005
R76 VSS.n7 VSS 5.2005
R77 VSS.n23 VSS.n22 5.2005
R78 VSS.n4 VSS 1.074
R79 VSS.n23 VSS.n2 5.2005
R80 VSS.n2 VSS 5.2005
R81 VSS VSS.n21 5.2005
R82 VSS VSS.n6 5.2005
R83 VSS.n12 VSS.n11 5.2005
R84 VSS.n19 VSS.n18 5.2005
R85 VSS.n1 VSS.n0 1.27115
R86 VSS.n20 VSS.n8 5.2005
R87 VSS.n20 VSS.n1 2.66071
R88 VSS.n5 VSS.n8 5.2005
R89 VSS VSS.n5 5.2005
R90 VSS.n18 VSS.n17 5.2005
R91 VSS.n17 VSS 5.2005
R92 VSS.n13 VSS.n12 5.2005
R93 VSS.n3 VSS.n10 4.5995
R94 VSS.n3 VSS.t1 4.4105
R95 VSS.n4 VSS.n3 1.42802
R96 VSS.n3 VSS.n2 2.71962
R97 VSS.n24 VSS.n7 2.66071
R98 VSS.n6 VSS.n9 2.66071
R99 VSS.n21 VSS.n9 2.66071
R100 VSS.n25 VSS.n24 2.66071
R101 VSS.n14 VSS.n11 2.63361
R102 VSS.n16 VSS.n13 2.63361
R103 VSS VSS.n16 1.53032
R104 VSS.n14 VSS.n0 1.53032
R105 VSS.n24 VSS.n23 1.27115
R106 VSS.n23 VSS.n9 1.27115
R107 VSS VSS.n0 1.00862
C0 VDD Y 0.52772f
C1 a_93_147# VDD 0.43757f
C2 a_93_147# Y 0.3652f
C3 Y VSS 0.90396f
C4 VDD VSS 2.34359f
C5 a_93_147# VSS 0.72927f
C6 VDD.n0 VSS 0.1372f
C7 VDD.n28 VSS 0.1372f
C8 Y.n0 VSS 0.15298f
.ends
