* NGSPICE file created from gf180mcu_ocd_sc_rt12t3v3__dff_1.ext - technology: gf180mcuD

.subckt gf180mcu_ocd_sc_rt12t3v3__dff_1 D CLK Q QN VDD VSS
X0 a_828_987.t1 CLKb.t7 in1.t4 VDD.t35 pfet_03v3 ad=0.5654p pd=3.45u as=0.3341p ps=1.805u w=1.285u l=0.28u
X1 out1 in1.t8 VDD.t32 VDD.t31 pfet_03v3 ad=0.3341p pd=1.805u as=0.5654p ps=3.45u w=1.285u l=0.28u
X2 a_2812_987.t3 out1 VDD.t30 VDD.t29 pfet_03v3 ad=0.3341p pd=1.805u as=0.3341p ps=1.805u w=1.285u l=0.28u
X3 a_4028_987.t0 out2.t7 VDD.t3 VDD.t2 pfet_03v3 ad=0.3341p pd=1.805u as=0.3341p ps=1.805u w=1.285u l=0.28u
X4 CLKN CLK.t2 VDD.t8 VDD.t7 pfet_03v3 ad=0.3341p pd=1.805u as=19.0728p ps=0.12486m w=1.285u l=0.28u
X5 VDD.t18 CLKN CLKb.t1 VDD.t17 pfet_03v3 ad=0.5654p pd=3.45u as=0.3341p ps=1.805u w=1.285u l=0.28u
X6 VDD.t41 D.t2 a_828_987.t2 VDD.t40 pfet_03v3 ad=0.3341p pd=1.805u as=0.5654p ps=3.45u w=1.285u l=0.28u
X7 out2.t2 in2.t7 VDD.t6 VDD.t5 pfet_03v3 ad=0.5654p pd=3.45u as=0.3341p ps=1.805u w=1.285u l=0.28u
X8 in1.t1 CLKN a_945_203r# VSS.t12 nfet_03v3 ad=0.3087p pd=2.01u as=0.52065p ps=3.23u w=1.02u l=0.28u
X9 VDD.t24 out1 a_2044_987.t2 VDD.t23 pfet_03v3 ad=0.3341p pd=1.805u as=0.5654p ps=3.45u w=1.285u l=0.28u
X10 a_2044_987.t0 CLKN in1.t3 VDD.t20 pfet_03v3 ad=0.5654p pd=3.45u as=0.3341p ps=1.805u w=1.285u l=0.28u
X11 VDD.t26 out1 a_2812_987.t2 VDD.t25 pfet_03v3 ad=0.3341p pd=1.805u as=0.5654p ps=3.45u w=1.285u l=0.28u
X12 Q.t0 QN.t5 VDD.t37 VDD.t36 pfet_03v3 ad=0.3341p pd=1.805u as=0.3341p ps=1.805u w=1.285u l=0.28u
X13 QN.t1 out2.t3 VSS.t9 VSS.t8 nfet_03v3 ad=0.3087p pd=2.01u as=2.74232p ps=14.88u w=1.02u l=0.28u
X14 a_2044_987.t3 out1 VDD.t28 VDD.t27 pfet_03v3 ad=0.3341p pd=1.805u as=0.3341p ps=1.805u w=1.285u l=0.28u
X15 in2.t5 CLKb.t3 a_2903_203r# VSS.t18 nfet_03v3 ad=0.3087p pd=2.01u as=0.52065p ps=3.23u w=1.02u l=0.28u
X16 Q.t1 QN.t3 VSS.t21 VSS.t20 nfet_03v3 ad=0.3087p pd=2.01u as=3.08512p ps=16.74u w=1.02u l=0.28u
X17 a_2135_203r# out1 VSS.t15 VSS.t14 nfet_03v3 ad=0.3087p pd=2.01u as=2.74232p ps=14.88u w=1.02u l=0.28u
X18 a_2903_203r# out1 VSS.t17 VSS.t16 nfet_03v3 ad=0.3087p pd=2.01u as=2.74232p ps=14.88u w=1.02u l=0.28u
X19 a_828_987.t3 D.t1 VDD.t43 VDD.t42 pfet_03v3 ad=0.3341p pd=1.805u as=0.3341p ps=1.805u w=1.285u l=0.28u
X20 CLKN CLK.t0 VSS.t5 VSS.t4 nfet_03v3 ad=0.3087p pd=2.01u as=3.08512p ps=16.74u w=1.02u l=0.28u
X21 out1 in1.t6 VSS.t7 VSS.t6 nfet_03v3 ad=0.3087p pd=2.015u as=3.08512p ps=16.74u w=1.02u l=0.28u
X22 VDD.t45 in1.t7 out1 VDD.t44 pfet_03v3 ad=0.5654p pd=3.45u as=0.3341p ps=1.805u w=1.285u l=0.28u
X23 VDD.t39 QN.t4 Q.t2 VDD.t38 pfet_03v3 ad=0.5654p pd=3.45u as=0.3341p ps=1.805u w=1.285u l=0.28u
X24 in2.t0 CLKb.t6 a_4028_987.t1 VDD.t4 pfet_03v3 ad=0.3341p pd=1.805u as=0.3341p ps=1.805u w=1.285u l=0.28u
X25 in2.t2 CLKN a_2812_987.t1 VDD.t21 pfet_03v3 ad=0.3341p pd=1.805u as=0.3341p ps=1.805u w=1.285u l=0.28u
X26 VDD.t10 CLK.t1 CLKN VDD.t9 pfet_03v3 ad=0.3341p pd=1.805u as=0.3341p ps=1.805u w=1.285u l=0.28u
X27 in1.t5 CLKb.t4 a_2135_203r# VSS.t19 nfet_03v3 ad=0.3087p pd=2.01u as=0.52065p ps=3.23u w=1.02u l=0.28u
X28 a_4028_987.t2 CLKb.t5 in2.t1 VDD.t11 pfet_03v3 ad=0.5654p pd=3.45u as=0.3341p ps=1.805u w=1.285u l=0.28u
X29 a_2812_987.t0 CLKN in2.t3 VDD.t22 pfet_03v3 ad=0.5654p pd=3.45u as=0.3341p ps=1.805u w=1.285u l=0.28u
X30 QN.t0 out2.t6 VDD.t13 VDD.t12 pfet_03v3 ad=0.3341p pd=1.805u as=0.5654p ps=3.45u w=1.285u l=0.28u
X31 CLKb.t0 CLKN VDD.t16 VDD.t15 pfet_03v3 ad=0.3341p pd=1.805u as=0.3341p ps=1.805u w=1.285u l=0.28u
X32 CLKb.t2 CLKN VSS.t11 VSS.t10 nfet_03v3 ad=0.3087p pd=2.01u as=3.08512p ps=16.74u w=1.02u l=0.28u
X33 VDD.t1 in2.t8 out2.t0 VDD.t0 pfet_03v3 ad=0.3341p pd=1.805u as=0.5654p ps=3.45u w=1.285u l=0.28u
X34 in1.t2 CLKN a_2044_987.t1 VDD.t19 pfet_03v3 ad=0.3341p pd=1.805u as=0.3341p ps=1.805u w=1.285u l=0.28u
X35 in1.t0 CLKb.t8 a_828_987.t0 VDD.t14 pfet_03v3 ad=0.3341p pd=1.805u as=0.3341p ps=1.805u w=1.285u l=0.28u
X36 VDD.t34 out2.t5 QN.t2 VDD.t33 pfet_03v3 ad=0.3341p pd=1.805u as=0.3341p ps=1.805u w=1.285u l=0.28u
X37 in2.t4 CLKN a_4107_203r# VSS.t13 nfet_03v3 ad=0.3087p pd=2.01u as=0.53235p ps=3.25u w=1.02u l=0.28u
X38 a_945_203r# D.t0 VSS.t23 VSS.t22 nfet_03v3 ad=0.3087p pd=2.01u as=3.08512p ps=16.74u w=1.02u l=0.28u
X39 VDD.t47 out2.t8 a_4028_987.t3 VDD.t46 pfet_03v3 ad=0.3341p pd=1.805u as=0.5654p ps=3.45u w=1.285u l=0.28u
X40 out2.t1 in2.t6 VSS.t1 VSS.t0 nfet_03v3 ad=0.3087p pd=2.015u as=3.08512p ps=16.74u w=1.02u l=0.28u
X41 a_4107_203r# out2.t4 VSS.t3 VSS.t2 nfet_03v3 ad=0.3087p pd=2.01u as=2.74232p ps=14.88u w=1.02u l=0.28u
R0 Q.t1 Q.n1 3.32853
R1 Q Q.n0 2.92847
R2 Q.n0 Q.t0 1.41684
R3 Q.n0 Q.t2 1.41684
R4 Q Q.t1 7.28055
R5 QN.n1 QN.t4 41.7438
R6 QN.n1 QN.t5 38.0938
R7 QN QN.n1 4.22746
R8 QN.t1 QN.n2 3.32853
R9 QN QN.t3 6.08857
R10 QN.n0 QN.t0 1.41684
R11 QN.n0 QN.t2 1.41684
R12 QN QN.t1 7.38701
R13 QN QN.n0 3.9218
R14 D.n0 D.t1 31.3586
R15 D.n0 D.t2 23.4503
R16 D D.n0 13.8634
R17 D D.t0 6.28719
R18 CLK.n0 CLK.t1 40.1505
R19 CLK.n0 CLK.t2 19.2934
R20 CLK CLK.n0 15.7625
R21 CLK CLK.t0 6.59728
R22 VDD.n135 VDD.n134 796.235
R23 VDD.n140 VDD.n36 137.088
R24 VDD.t9 VDD.n76 137.088
R25 VDD.t9 VDD.n75 137.088
R26 VDD.n81 VDD.n80 137.088
R27 VDD.n81 VDD.n72 137.088
R28 VDD.n86 VDD.n85 137.088
R29 VDD.n90 VDD.n89 137.088
R30 VDD.n91 VDD.n90 137.088
R31 VDD.n95 VDD.n94 137.088
R32 VDD.n96 VDD.n95 137.088
R33 VDD.n100 VDD.n99 137.088
R34 VDD.n104 VDD.n58 137.088
R35 VDD.n105 VDD.n104 137.088
R36 VDD.t21 VDD.n55 137.088
R37 VDD.n109 VDD.t21 137.088
R38 VDD.n110 VDD.n52 137.088
R39 VDD.t0 VDD.n52 137.088
R40 VDD.n113 VDD.t0 137.088
R41 VDD.n114 VDD.n49 137.088
R42 VDD.t46 VDD.n49 137.088
R43 VDD.n117 VDD.t46 137.088
R44 VDD.n121 VDD.n46 137.088
R45 VDD.n123 VDD.n122 137.088
R46 VDD.n126 VDD.n43 137.088
R47 VDD.n128 VDD.n42 137.088
R48 VDD.n132 VDD.n131 137.088
R49 VDD.t17 VDD.n79 117.504
R50 VDD.t42 VDD.n84 117.504
R51 VDD.n101 VDD.t19 117.504
R52 VDD.n106 VDD.t25 117.504
R53 VDD.n118 VDD.t4 117.504
R54 VDD.n123 VDD.t12 117.504
R55 VDD.n131 VDD.t38 117.504
R56 VDD.t14 VDD.n69 97.9197
R57 VDD.n69 VDD.t35 97.9197
R58 VDD.t31 VDD.n66 97.9197
R59 VDD.n66 VDD.t44 97.9197
R60 VDD.t23 VDD.n64 97.9197
R61 VDD.n64 VDD.t27 97.9197
R62 VDD.n122 VDD.t11 97.9197
R63 VDD.n127 VDD.t33 97.9197
R64 VDD.t36 VDD.n127 97.9197
R65 VDD.t7 VDD.n36 78.3359
R66 VDD.n79 VDD.t15 78.3359
R67 VDD.n84 VDD.t40 78.3359
R68 VDD.n101 VDD.t20 78.3359
R69 VDD.n106 VDD.t29 78.3359
R70 VDD.n110 VDD.t22 78.3359
R71 VDD.n114 VDD.t5 78.3359
R72 VDD.n118 VDD.t2 78.3359
R73 VDD.n76 VDD.t7 58.752
R74 VDD.n75 VDD.t15 58.752
R75 VDD.n72 VDD.t40 58.752
R76 VDD.t20 VDD.n58 58.752
R77 VDD.t29 VDD.n55 58.752
R78 VDD.t22 VDD.n109 58.752
R79 VDD.t5 VDD.n113 58.752
R80 VDD.t2 VDD.n117 58.752
R81 VDD.n86 VDD.t14 39.1682
R82 VDD.n89 VDD.t35 39.1682
R83 VDD.n91 VDD.t31 39.1682
R84 VDD.n94 VDD.t44 39.1682
R85 VDD.n96 VDD.t23 39.1682
R86 VDD.n99 VDD.t27 39.1682
R87 VDD.t11 VDD.n121 39.1682
R88 VDD.t33 VDD.n126 39.1682
R89 VDD.n128 VDD.t36 39.1682
R90 VDD.n80 VDD.t17 19.5843
R91 VDD.n85 VDD.t42 19.5843
R92 VDD.t19 VDD.n100 19.5843
R93 VDD.t25 VDD.n105 19.5843
R94 VDD.t4 VDD.n46 19.5843
R95 VDD.t12 VDD.n43 19.5843
R96 VDD.n42 VDD.t38 19.5843
R97 VDD.n6 VDD.n133 5.514
R98 VDD.n37 VDD.n7 4.93411
R99 VDD.n141 VDD.n34 9.8005
R100 VDD.n74 VDD.n34 9.8005
R101 VDD.n77 VDD.n74 9.8005
R102 VDD.n77 VDD.n29 2.75725
R103 VDD.n78 VDD.n33 9.8005
R104 VDD.n78 VDD.n71 9.8005
R105 VDD.n82 VDD.n32 2.75725
R106 VDD.n82 VDD.n9 9.8005
R107 VDD.n83 VDD.n9 9.8005
R108 VDD.n26 VDD.n68 2.75725
R109 VDD.n87 VDD.n68 9.8005
R110 VDD.n87 VDD.n67 9.8005
R111 VDD.n88 VDD.n10 2.75725
R112 VDD.n88 VDD.n65 9.8005
R113 VDD.n92 VDD.n31 2.75725
R114 VDD.n92 VDD.n11 9.8005
R115 VDD.n93 VDD.n11 9.8005
R116 VDD.n30 VDD.n63 2.75725
R117 VDD.n97 VDD.n63 9.8005
R118 VDD.n97 VDD.n61 9.8005
R119 VDD.n98 VDD.n12 2.75725
R120 VDD.n98 VDD.n60 9.8005
R121 VDD.n102 VDD.n13 2.75725
R122 VDD.n102 VDD.n59 9.8005
R123 VDD.n103 VDD.n14 2.75725
R124 VDD.n103 VDD.n57 9.8005
R125 VDD.n107 VDD.n25 2.75725
R126 VDD.n107 VDD.n15 9.8005
R127 VDD.n108 VDD.n15 9.8005
R128 VDD.n16 VDD.n54 2.75725
R129 VDD.n111 VDD.n54 9.8005
R130 VDD.n18 VDD.n17 2.75725
R131 VDD.n112 VDD.n17 9.8005
R132 VDD.n28 VDD.n51 2.75725
R133 VDD.n115 VDD.n51 9.8005
R134 VDD.n20 VDD.n19 2.75725
R135 VDD.n116 VDD.n19 9.8005
R136 VDD.n27 VDD.n48 2.75725
R137 VDD.n119 VDD.n48 9.8005
R138 VDD.n119 VDD.n47 9.8005
R139 VDD.n120 VDD.n21 2.75725
R140 VDD.n120 VDD.n45 9.8005
R141 VDD.n124 VDD.n45 9.8005
R142 VDD.n124 VDD.n24 2.75725
R143 VDD.n125 VDD.n44 9.8005
R144 VDD.n22 VDD.n41 2.75725
R145 VDD.n129 VDD.n41 9.8005
R146 VDD.n129 VDD.n39 9.8005
R147 VDD.n23 VDD.n39 2.75725
R148 VDD.n130 VDD.n8 9.8005
R149 VDD.n138 VDD.n4 7.02237
R150 VDD.n134 VDD.n2 6.51963
R151 VDD.n141 VDD.n35 6.388
R152 VDD.n141 VDD.n140 6.3005
R153 VDD VDD.n141 6.3005
R154 VDD.n36 VDD.n34 6.3005
R155 VDD VDD.n34 6.3005
R156 VDD.n76 VDD.n74 6.3005
R157 VDD.n74 VDD 6.3005
R158 VDD.n77 VDD.t9 6.3005
R159 VDD VDD.n29 1.77287
R160 VDD.n75 VDD.n33 6.3005
R161 VDD.n29 VDD.n33 2.75725
R162 VDD.n79 VDD.n78 6.3005
R163 VDD.n78 VDD.n3 6.3005
R164 VDD.n80 VDD.n71 6.3005
R165 VDD.n32 VDD.n71 2.75725
R166 VDD.n82 VDD.n81 6.3005
R167 VDD.n3 VDD.n32 1.77287
R168 VDD.n72 VDD.n9 6.3005
R169 VDD.n3 VDD.n9 6.3005
R170 VDD.n84 VDD.n83 6.3005
R171 VDD.n83 VDD.n26 2.75725
R172 VDD.n85 VDD.n68 6.3005
R173 VDD.n26 VDD.n3 1.77287
R174 VDD.n87 VDD.n86 6.3005
R175 VDD.n3 VDD.n87 6.3005
R176 VDD.n69 VDD.n67 6.3005
R177 VDD.n10 VDD.n67 2.75725
R178 VDD.n89 VDD.n88 6.3005
R179 VDD.n10 VDD.n0 1.77287
R180 VDD.n90 VDD.n65 6.3005
R181 VDD.n31 VDD.n65 2.75725
R182 VDD.n92 VDD.n91 6.3005
R183 VDD.n0 VDD.n31 1.77287
R184 VDD.n66 VDD.n11 6.3005
R185 VDD.n0 VDD.n11 6.3005
R186 VDD.n94 VDD.n93 6.3005
R187 VDD.n93 VDD.n30 2.75725
R188 VDD.n95 VDD.n63 6.3005
R189 VDD.n30 VDD.n0 1.77287
R190 VDD.n97 VDD.n96 6.3005
R191 VDD.n0 VDD.n97 6.3005
R192 VDD.n64 VDD.n61 6.3005
R193 VDD.n12 VDD.n61 2.75725
R194 VDD.n99 VDD.n98 6.3005
R195 VDD.n12 VDD.n0 1.77287
R196 VDD.n100 VDD.n60 6.3005
R197 VDD.n60 VDD.n13 2.75725
R198 VDD.n102 VDD.n101 6.3005
R199 VDD.n0 VDD.n13 1.77287
R200 VDD.n59 VDD.n58 6.3005
R201 VDD.n14 VDD.n59 2.75725
R202 VDD.n104 VDD.n103 6.3005
R203 VDD.n14 VDD.n0 1.77287
R204 VDD.n105 VDD.n57 6.3005
R205 VDD.n25 VDD.n57 2.75725
R206 VDD.n107 VDD.n106 6.3005
R207 VDD.n0 VDD.n25 1.77287
R208 VDD.n15 VDD.n55 6.3005
R209 VDD.n0 VDD.n15 6.3005
R210 VDD.t21 VDD.n108 6.3005
R211 VDD.n108 VDD.n16 2.75725
R212 VDD.n109 VDD.n54 6.3005
R213 VDD.n16 VDD.n0 1.77287
R214 VDD.n111 VDD.n110 6.3005
R215 VDD.n18 VDD.n111 2.75725
R216 VDD.n17 VDD.n52 6.3005
R217 VDD.n0 VDD.n18 1.77287
R218 VDD.t0 VDD.n112 6.3005
R219 VDD.n112 VDD.n28 2.75725
R220 VDD.n113 VDD.n51 6.3005
R221 VDD.n28 VDD.n1 1.77287
R222 VDD.n115 VDD.n114 6.3005
R223 VDD.n20 VDD.n115 2.75725
R224 VDD.n19 VDD.n49 6.3005
R225 VDD.n1 VDD.n20 1.77287
R226 VDD.t46 VDD.n116 6.3005
R227 VDD.n116 VDD.n27 2.75725
R228 VDD.n117 VDD.n48 6.3005
R229 VDD.n27 VDD.n1 1.77287
R230 VDD.n119 VDD.n118 6.3005
R231 VDD.n1 VDD.n119 6.3005
R232 VDD.n47 VDD.n46 6.3005
R233 VDD.n21 VDD.n47 2.75725
R234 VDD.n121 VDD.n120 6.3005
R235 VDD.n21 VDD.n1 1.77287
R236 VDD.n122 VDD.n45 6.3005
R237 VDD.n45 VDD.n1 6.3005
R238 VDD.n124 VDD.n123 6.3005
R239 VDD.n1 VDD.n24 1.77287
R240 VDD.n44 VDD.n43 6.3005
R241 VDD.n24 VDD.n44 2.75725
R242 VDD.n126 VDD.n125 6.3005
R243 VDD.n125 VDD.n22 2.75725
R244 VDD.n127 VDD.n41 6.3005
R245 VDD.n22 VDD.n2 1.77287
R246 VDD.n129 VDD.n128 6.3005
R247 VDD.n2 VDD.n129 6.3005
R248 VDD.n42 VDD.n39 6.3005
R249 VDD.n2 VDD.n23 1.77287
R250 VDD.n131 VDD.n130 6.3005
R251 VDD.n130 VDD.n23 2.75725
R252 VDD.n2 VDD.n8 6.3005
R253 VDD.n35 VDD 6.3005
R254 VDD.n4 VDD.n5 0.784727
R255 VDD VDD.n138 6.3005
R256 VDD.n140 VDD.n135 6.3005
R257 VDD.n6 VDD.n2 1.77287
R258 VDD.n6 VDD.n38 5.514
R259 VDD.n2 VDD.n7 1.77287
R260 VDD.n1 VDD.n50 5.42746
R261 VDD.n1 VDD.n53 5.42746
R262 VDD.n0 VDD.n56 5.42746
R263 VDD.n3 VDD.n70 5.42746
R264 VDD.n0 VDD.n62 5.42746
R265 VDD.n137 VDD.n136 5.4131
R266 VDD.n0 VDD.t45 4.32989
R267 VDD.n0 VDD.t32 4.32989
R268 VDD.n1 VDD.t13 4.32793
R269 VDD.n2 VDD.t39 4.32597
R270 VDD.n3 VDD.t18 4.32597
R271 VDD VDD.n73 2.91159
R272 VDD.n5 VDD 1.74437
R273 VDD.n2 VDD.n40 2.91159
R274 VDD.n137 VDD.n135 2.82549
R275 VDD.n134 VDD.n133 2.75725
R276 VDD.n7 VDD.n38 5.514
R277 VDD.n138 VDD.n136 2.68305
R278 VDD.n139 VDD.n35 2.32205
R279 VDD.n139 VDD.n4 2.32205
R280 VDD.n8 VDD.n37 2.17736
R281 VDD.n132 VDD.n37 2.06282
R282 VDD VDD.n137 2.03587
R283 VDD.n140 VDD.n139 1.99047
R284 VDD.n1 VDD.n0 1.8485
R285 VDD.n140 VDD.n136 1.80997
R286 VDD.n133 VDD.n132 1.77287
R287 VDD.n132 VDD.n38 1.77287
R288 VDD.n50 VDD.t47 1.41684
R289 VDD.n50 VDD.t3 1.41684
R290 VDD.n53 VDD.t1 1.41684
R291 VDD.n53 VDD.t6 1.41684
R292 VDD.n56 VDD.t26 1.41684
R293 VDD.n56 VDD.t30 1.41684
R294 VDD.n70 VDD.t41 1.41684
R295 VDD.n70 VDD.t43 1.41684
R296 VDD.n73 VDD.t10 1.41684
R297 VDD.n73 VDD.t16 1.41684
R298 VDD.n5 VDD.t8 1.77948
R299 VDD.n40 VDD.t34 1.41684
R300 VDD.n40 VDD.t37 1.41684
R301 VDD.n62 VDD.t24 1.41684
R302 VDD.n62 VDD.t28 1.41684
R303 VDD.n2 VDD.n1 1.34763
R304 VDD.n0 VDD.n3 1.1765
R305 VDD.n3 VDD 1.1285
R306 VSS.n151 VSS.n150 897.538
R307 VSS.n154 VSS.n153 513.399
R308 VSS.n87 VSS.n86 513.399
R309 VSS.n87 VSS.n85 513.399
R310 VSS.n91 VSS.n90 513.399
R311 VSS.n91 VSS.n82 513.399
R312 VSS.n94 VSS.n82 513.399
R313 VSS.n95 VSS.n80 513.399
R314 VSS.n97 VSS.n80 513.399
R315 VSS.n99 VSS.n98 513.399
R316 VSS.n99 VSS.n77 513.399
R317 VSS.n102 VSS.n77 513.399
R318 VSS.n104 VSS.n103 513.399
R319 VSS.n104 VSS.n76 513.399
R320 VSS.n108 VSS.n107 513.399
R321 VSS.n109 VSS.n108 513.399
R322 VSS.n109 VSS.n73 513.399
R323 VSS.n113 VSS.n112 513.399
R324 VSS.n114 VSS.n113 513.399
R325 VSS.n118 VSS.n69 513.399
R326 VSS.n119 VSS.n118 513.399
R327 VSS.n120 VSS.n119 513.399
R328 VSS.n123 VSS.n66 513.399
R329 VSS.n124 VSS.n123 513.399
R330 VSS.n125 VSS.n64 513.399
R331 VSS.n128 VSS.n64 513.399
R332 VSS.n129 VSS.n128 513.399
R333 VSS.n130 VSS.n62 513.399
R334 VSS.n133 VSS.n62 513.399
R335 VSS.n134 VSS.n133 513.399
R336 VSS.n135 VSS.n58 513.399
R337 VSS.n138 VSS.n58 513.399
R338 VSS.n140 VSS.n139 513.399
R339 VSS.n140 VSS.n57 513.399
R340 VSS.n144 VSS.n143 513.399
R341 VSS.n145 VSS.n144 513.399
R342 VSS.n145 VSS.n54 513.399
R343 VSS.n135 VSS.t13 495.063
R344 VSS.n76 VSS.t14 490.481
R345 VSS.n103 VSS.t6 458.392
R346 VSS.n114 VSS.t16 417.137
R347 VSS.t12 VSS.n97 412.553
R348 VSS.n85 VSS.t10 380.466
R349 VSS.t18 VSS.n66 366.714
R350 VSS.n95 VSS.t22 343.795
R351 VSS.n139 VSS.t8 343.795
R352 VSS.t0 VSS.n124 339.211
R353 VSS.n57 VSS.t20 325.459
R354 VSS.n112 VSS.t19 293.372
R355 VSS.n86 VSS.t4 288.788
R356 VSS.t2 VSS.n129 288.788
R357 VSS.n154 VSS.t4 224.613
R358 VSS.n130 VSS.t2 224.613
R359 VSS.n73 VSS.t19 220.029
R360 VSS.n143 VSS.t20 187.941
R361 VSS.n125 VSS.t0 174.19
R362 VSS.t22 VSS.n94 169.606
R363 VSS.t8 VSS.n138 169.606
R364 VSS.n120 VSS.t18 146.685
R365 VSS.n90 VSS.t10 132.935
R366 VSS.n98 VSS.t12 100.847
R367 VSS.t16 VSS.n69 96.2628
R368 VSS.t6 VSS.n102 55.0075
R369 VSS.n107 VSS.t14 22.9201
R370 VSS.t13 VSS.n134 18.3362
R371 VSS.n146 VSS.n36 2.66071
R372 VSS.n132 VSS.n61 10.8894
R373 VSS.n136 VSS.n35 2.66071
R374 VSS.n136 VSS.n60 10.8894
R375 VSS.n127 VSS.n50 10.8894
R376 VSS.n121 VSS.n68 10.8894
R377 VSS.n121 VSS.n67 10.8894
R378 VSS.n122 VSS.n34 2.66071
R379 VSS.n122 VSS.n48 10.8894
R380 VSS.n110 VSS.n72 10.8894
R381 VSS.n111 VSS.n32 2.66071
R382 VSS.n111 VSS.n71 10.8894
R383 VSS.n115 VSS.n33 2.66071
R384 VSS.n105 VSS.n75 10.8894
R385 VSS.n29 VSS.n79 2.66071
R386 VSS.n100 VSS.n79 10.8894
R387 VSS.n31 VSS.n30 2.66071
R388 VSS.n155 VSS.n53 10.8894
R389 VSS.n141 VSS.n49 10.8507
R390 VSS.n96 VSS.n52 10.8507
R391 VSS.n137 VSS.n38 2.6499
R392 VSS.n93 VSS.n43 10.7992
R393 VSS.n88 VSS.n40 2.63743
R394 VSS.n26 VSS.n12 2.61532
R395 VSS.n101 VSS.n30 10.4771
R396 VSS.n146 VSS.n51 10.4126
R397 VSS.n27 VSS.n14 2.59768
R398 VSS.n45 VSS.n75 2.58307
R399 VSS.n44 VSS.n43 2.58307
R400 VSS.n46 VSS.n68 2.56994
R401 VSS.n116 VSS.n115 10.0519
R402 VSS.n110 VSS.n28 2.54328
R403 VSS.n89 VSS.n47 9.94879
R404 VSS.n126 VSS.n37 2.52805
R405 VSS.n142 VSS.n41 2.52293
R406 VSS.n39 VSS.n20 2.51436
R407 VSS.n131 VSS.n42 2.50919
R408 VSS.n137 VSS.n5 9.27761
R409 VSS.n93 VSS.n4 9.27761
R410 VSS.n88 VSS.n0 8.60291
R411 VSS.n13 VSS.n12 7.42219
R412 VSS.n25 VSS.n53 7.38939
R413 VSS.n147 VSS.n55 7.38939
R414 VSS.n101 VSS.n22 2.40308
R415 VSS.n11 VSS.n51 2.32493
R416 VSS.n15 VSS.n14 6.49448
R417 VSS.n106 VSS.n19 5.73544
R418 VSS.n92 VSS.n23 5.73544
R419 VSS VSS.n151 5.41963
R420 VSS.n150 VSS.n1 5.41963
R421 VSS.n155 VSS.n154 5.2005
R422 VSS VSS.n155 3.00607
R423 VSS.n153 VSS.n53 5.2005
R424 VSS.n53 VSS 5.2005
R425 VSS.n88 VSS.n87 5.2005
R426 VSS VSS.n40 1.28278
R427 VSS.n86 VSS.n0 5.2005
R428 VSS.n85 VSS.n47 5.2005
R429 VSS.n40 VSS.n47 2.63743
R430 VSS.n92 VSS.n91 5.2005
R431 VSS.n44 VSS.n92 2.58307
R432 VSS.n90 VSS.n89 5.2005
R433 VSS.n89 VSS.n24 1.57624
R434 VSS.n43 VSS.n82 5.2005
R435 VSS VSS.n44 1.30997
R436 VSS.n4 VSS.n95 5.2005
R437 VSS.n94 VSS.n93 5.2005
R438 VSS.n93 VSS 5.2005
R439 VSS.n30 VSS.n77 5.2005
R440 VSS VSS.n31 1.27115
R441 VSS.n100 VSS.n99 5.2005
R442 VSS.n31 VSS.n100 2.66071
R443 VSS.n98 VSS.n79 5.2005
R444 VSS.n29 VSS 1.27115
R445 VSS.n97 VSS.n96 5.2005
R446 VSS.n96 VSS.n29 2.66071
R447 VSS.n52 VSS.n80 5.2005
R448 VSS.n103 VSS.n20 5.2005
R449 VSS VSS.n39 1.34432
R450 VSS.n102 VSS.n101 5.2005
R451 VSS.n22 VSS 1.0565
R452 VSS.n76 VSS.n75 5.2005
R453 VSS.n2 VSS.n45 1.30997
R454 VSS.n105 VSS.n104 5.2005
R455 VSS.n39 VSS.n105 2.51436
R456 VSS.n108 VSS.n18 5.2005
R457 VSS.n28 VSS.n18 2.54328
R458 VSS.n107 VSS.n106 5.2005
R459 VSS.n106 VSS.n45 2.58307
R460 VSS.n115 VSS.n114 5.2005
R461 VSS.n33 VSS.n2 1.27115
R462 VSS.n113 VSS.n71 5.2005
R463 VSS.n33 VSS.n71 2.66071
R464 VSS.n112 VSS.n111 5.2005
R465 VSS.n32 VSS.n2 1.27115
R466 VSS.n73 VSS.n72 5.2005
R467 VSS.n32 VSS.n72 2.66071
R468 VSS.n110 VSS.n109 5.2005
R469 VSS.n2 VSS.n28 1.32986
R470 VSS.n118 VSS.n117 5.2005
R471 VSS.n117 VSS.n46 2.56994
R472 VSS.n116 VSS.n69 5.2005
R473 VSS.n17 VSS.n116 1.76546
R474 VSS.n124 VSS.n48 5.2005
R475 VSS.n37 VSS.n48 2.52805
R476 VSS.n123 VSS.n122 5.2005
R477 VSS.n34 VSS.n2 1.27115
R478 VSS.n67 VSS.n66 5.2005
R479 VSS.n34 VSS.n67 2.66071
R480 VSS.n121 VSS.n120 5.2005
R481 VSS.n2 VSS.n121 5.2005
R482 VSS.n119 VSS.n68 5.2005
R483 VSS.n46 VSS.n2 1.31653
R484 VSS.n14 VSS.n64 5.2005
R485 VSS.n2 VSS.n27 1.30266
R486 VSS.n126 VSS.n125 5.2005
R487 VSS.n37 VSS.n2 1.33747
R488 VSS.n129 VSS.n50 5.2005
R489 VSS.n42 VSS.n50 2.50919
R490 VSS.n128 VSS.n127 5.2005
R491 VSS.n127 VSS.n27 2.59768
R492 VSS.n12 VSS.n62 5.2005
R493 VSS.n2 VSS.n26 1.29384
R494 VSS.n131 VSS.n130 5.2005
R495 VSS.n42 VSS.n2 1.3469
R496 VSS.n60 VSS.n58 5.2005
R497 VSS.n38 VSS.n60 2.6499
R498 VSS.n136 VSS.n135 5.2005
R499 VSS.n1 VSS.n35 1.27115
R500 VSS.n134 VSS.n61 5.2005
R501 VSS.n61 VSS.n35 2.66071
R502 VSS.n133 VSS.n132 5.2005
R503 VSS.n132 VSS.n26 2.61532
R504 VSS.n139 VSS.n5 5.2005
R505 VSS.n138 VSS.n137 5.2005
R506 VSS.n38 VSS.n1 1.27655
R507 VSS.n57 VSS.n49 5.2005
R508 VSS.n41 VSS.n49 2.52293
R509 VSS.n141 VSS.n140 5.2005
R510 VSS.n144 VSS.n51 5.2005
R511 VSS.n1 VSS.n11 1.08598
R512 VSS.n143 VSS.n142 5.2005
R513 VSS.n41 VSS.n1 1.34003
R514 VSS.n55 VSS.n54 5.2005
R515 VSS.n36 VSS.n55 2.66071
R516 VSS.n146 VSS.n145 5.2005
R517 VSS.n1 VSS.n36 1.27115
R518 VSS.n9 VSS.n1 1.27115
R519 VSS.n148 VSS.n9 5.32092
R520 VSS.n147 VSS.n1 5.2005
R521 VSS VSS.n25 5.2005
R522 VSS VSS.n8 1.27115
R523 VSS.n117 VSS.n16 5.06074
R524 VSS.n10 VSS.n56 4.5995
R525 VSS.n5 VSS.n59 4.5995
R526 VSS.n13 VSS.n63 4.5995
R527 VSS.n15 VSS.n65 4.5995
R528 VSS.n16 VSS.n70 4.5995
R529 VSS.n19 VSS.n74 4.5995
R530 VSS.n21 VSS.n78 4.5995
R531 VSS.n4 VSS.n81 4.5995
R532 VSS.n23 VSS.n83 4.5995
R533 VSS.n0 VSS.n84 4.5995
R534 VSS.n10 VSS.t21 4.4105
R535 VSS.n5 VSS.t9 4.4105
R536 VSS.n13 VSS.t3 4.4105
R537 VSS.n15 VSS.t1 4.4105
R538 VSS.n16 VSS.t17 4.4105
R539 VSS.n19 VSS.t15 4.4105
R540 VSS.n21 VSS.t7 4.4105
R541 VSS.n4 VSS.t23 4.4105
R542 VSS.n23 VSS.t11 4.4105
R543 VSS.n0 VSS.t5 4.4105
R544 VSS.n17 VSS.n16 1.13399
R545 VSS.n1 VSS 4.0535
R546 VSS.n1 VSS 3.776
R547 VSS.n19 VSS.n18 3.71134
R548 VSS.n2 VSS.n19 3.3395
R549 VSS.n2 VSS.n17 1.3444
R550 VSS.n24 VSS.n23 1.01248
R551 VSS.n24 VSS 1.41839
R552 VSS.n2 VSS 3.2075
R553 VSS.n4 VSS.n3 1.21585
R554 VSS.n22 VSS.n21 1.45611
R555 VSS.n2 VSS.n15 3.1505
R556 VSS.n2 VSS.n13 3.1505
R557 VSS.n6 VSS.n5 1.21585
R558 VSS.n11 VSS.n10 1.40876
R559 VSS.n15 VSS.n126 3.14131
R560 VSS.n142 VSS.n10 2.8883
R561 VSS.n2 VSS 2.87975
R562 VSS.n151 VSS.n7 2.66071
R563 VSS.n150 VSS.n149 2.66071
R564 VSS.n152 VSS.n25 2.66071
R565 VSS.n152 VSS.n8 5.32092
R566 VSS.n8 VSS.n7 5.32092
R567 VSS.n148 VSS.n147 2.66071
R568 VSS.n149 VSS.n9 5.32092
R569 VSS.n141 VSS.n6 3.00215
R570 VSS.n3 VSS.n52 3.00215
R571 VSS.n1 VSS 2.63542
R572 VSS VSS.n0 2.48229
R573 VSS.n21 VSS.n20 2.46661
R574 VSS.n1 VSS 2.44728
R575 VSS.n2 VSS 2.3045
R576 VSS.n13 VSS.n131 2.2136
R577 VSS.n2 VSS 2.06186
R578 VSS.n2 VSS 1.83965
R579 VSS.n2 VSS 1.7285
R580 VSS.n2 VSS 1.60083
R581 VSS.n2 VSS 1.44965
R582 VSS.n1 VSS.n6 1.32889
R583 VSS.n149 VSS.n54 1.27115
R584 VSS.n148 VSS.n54 1.27115
R585 VSS.n153 VSS.n152 1.27115
R586 VSS.n153 VSS.n7 1.27115
R587 VSS VSS.n3 1.20945
R588 VSS.n2 VSS 1.05914
R589 VSS.n2 VSS.n1 1.01339
R590 a_4028_987.n0 a_4028_987.t3 4.91293
R591 a_4028_987.n0 a_4028_987.t2 4.89923
R592 a_4028_987.n1 a_4028_987.n0 2.6005
R593 a_4028_987.n1 a_4028_987.t1 1.41684
R594 a_4028_987.t0 a_4028_987.n1 1.41684
R595 a_2812_987.n1 a_2812_987.t2 4.91293
R596 a_2812_987.t0 a_2812_987.n1 4.89923
R597 a_2812_987.n1 a_2812_987.n0 2.6005
R598 a_2812_987.n0 a_2812_987.t1 1.41684
R599 a_2812_987.n0 a_2812_987.t3 1.41684
R600 a_2044_987.n1 a_2044_987.t2 4.91293
R601 a_2044_987.t0 a_2044_987.n1 4.89923
R602 a_2044_987.n1 a_2044_987.n0 2.6005
R603 a_2044_987.n0 a_2044_987.t1 1.41684
R604 a_2044_987.n0 a_2044_987.t3 1.41684
R605 a_828_987.n0 a_828_987.t2 4.91293
R606 a_828_987.n0 a_828_987.t1 4.89923
R607 a_828_987.n1 a_828_987.n0 2.6005
R608 a_828_987.t0 a_828_987.n1 1.41684
R609 a_828_987.n1 a_828_987.t3 1.41684
R610 out2.n7 out2.n6 109.177
R611 out2.n6 out2.n5 51.1005
R612 out2.n2 out2.t5 42.3521
R613 out2.n12 out2.t7 38.5572
R614 out2.n2 out2.t6 37.4854
R615 out2.n11 out2.n0 3.41286
R616 out2.n12 out2.t8 19.2934
R617 out2 out2.n1 10.3473
R618 out2.n4 out2.n8 41.3549
R619 out2.n1 out2.n12 9.14178
R620 out2.n5 out2.t3 6.76732
R621 out2 out2.n0 7.24659
R622 out2.n6 out2.n4 5.23239
R623 out2.n10 out2.n2 4.85354
R624 out2.n9 out2.n8 4.83952
R625 out2.n1 out2.t0 4.68989
R626 out2.n10 out2.n9 4.58841
R627 out2.n1 out2.t2 4.1649
R628 out2.n9 out2.n3 3.87658
R629 out2.n8 out2.n7 3.50455
R630 out2.t1 out2.n0 0.653675
R631 out2 out2.t4 10.5281
R632 out2.t3 out2.n4 2.73523
R633 out2 out2.n10 1.96415
R634 out2.n7 out2.n3 1.57189
R635 out2.n5 out2.n3 1.29467
R636 in2.n4 in2.t7 37.891
R637 in2.n4 in2.t8 19.2934
R638 in2.n3 in2.t4 11.4691
R639 in2.n3 in2.n1 10.7372
R640 in2.n0 in2.n6 10.3205
R641 in2.n6 in2.n4 8.0394
R642 in2.n6 in2.n5 5.2005
R643 in2 in2.n3 5.12779
R644 in2.t4 in2.n2 3.1489
R645 in2.n0 in2.t6 6.99436
R646 in2.n0 in2.t5 6.98303
R647 in2 in2.n0 1.69192
R648 in2.n1 in2.t0 1.41684
R649 in2.n1 in2.t1 1.41684
R650 in2.n5 in2.t2 1.41684
R651 in2.n5 in2.t3 1.41684
R652 in1.n3 in1.t7 40.1505
R653 in1.n5 in1.n3 28.0278
R654 in1.n3 in1.t8 19.2934
R655 in1.n2 in1.t5 11.3048
R656 in1.n2 in1.n1 10.702
R657 in1.n0 in1.n5 8.14204
R658 in1 in1.n2 5.3195
R659 in1.n5 in1.n4 5.2005
R660 in1 in1.t6 9.58619
R661 in1.n0 in1.t1 6.98303
R662 in1 in1.n0 1.61473
R663 in1.n4 in1.t0 1.41684
R664 in1.n4 in1.t4 1.41684
R665 in1.n1 in1.t2 1.41684
R666 in1.n1 in1.t3 1.41684
R667 CLKb.n1 CLKb.t5 50.4632
R668 CLKb.n0 CLKb.t7 40.1505
R669 CLKb.n1 CLKb.t6 31.8076
R670 CLKb.n0 CLKb.t8 19.2934
R671 CLKb.n3 CLKb.t4 14.6129
R672 CLKb.n4 CLKb.n0 11.1192
R673 CLKb.n2 CLKb.n1 7.83926
R674 CLKb.n2 CLKb.t3 7.81384
R675 CLKb CLKb.n6 5.01887
R676 CLKb.t2 CLKb.n7 3.32853
R677 CLKb.n6 CLKb.n5 3.20364
R678 CLKb.n4 CLKb.n3 3.18376
R679 CLKb.n5 CLKb.t0 1.41684
R680 CLKb.n5 CLKb.t1 1.41684
R681 CLKb CLKb.t2 12.0115
R682 CLKb.n6 CLKb.n4 1.06289
R683 CLKb.n3 CLKb.n2 1.01985
C0 CLKb in2 1.12429f
C1 CLK VDD 0.58708f
C2 out1 VDD 1.00459f
C3 in2 CLKN 0.91472f
C4 Q VDD 0.55791f
C5 in1 VDD 0.50618f
C6 CLKb CLKN 1.80641f
C7 Q QN 0.52563f
C8 in1 D 0.10806f
C9 a_945_203r# D 0.1386f
C10 in2 VDD 0.50128f
C11 CLKb VDD 1.37955f
C12 CLKN VDD 1.76986f
C13 a_2903_203r# out1 0.13364f
C14 in2 out2 1.5669f
C15 in1 out1 1.49319f
C16 a_2135_203r# out1 0.36343f
C17 a_4107_203r# in2 0.15892f
C18 out2 CLKN 0.86265f
C19 CLKb D 0.40459f
C20 in1 a_945_203r# 0.1584f
C21 CLKN D 0.5238f
C22 CLKb out1 0.5922f
C23 CLKb in1 1.41885f
C24 out2 VDD 1.24664f
C25 CLK CLKN 0.48557f
C26 out1 CLKN 1.2713f
C27 QN VDD 0.82337f
C28 in1 CLKN 0.83329f
C29 D VDD 0.34242f
C30 QN out2 0.59218f
C31 a_4107_203r# out2 0.39879f
C32 Q VSS 0.90499f
C33 QN VSS 1.29134f
C34 D VSS 1.08552f
C35 CLK VSS 1.05011f
C36 VDD VSS 15.23846f
C37 a_4107_203r# VSS 0.10874f
C38 a_2903_203r# VSS 0.11031f
C39 a_2135_203r# VSS 0.10697f
C40 a_945_203r# VSS 0.11484f
C41 out2 VSS 2.01956f
C42 in2 VSS 0.9573f
C43 out1 VSS 1.0874f
C44 in1 VSS 1.57516f
C45 CLKb VSS 1.62215f
C46 CLKN VSS 1.58144f
C47 CLKb.t2 VSS 0.29298f
C48 CLKb.t7 VSS 0.1569f
C49 CLKb.n0 VSS 0.16921f
C50 CLKb.t6 VSS 0.12809f
C51 CLKb.t5 VSS 0.1806f
C52 CLKb.n1 VSS 0.44063f
C53 CLKb.t3 VSS 0.75853f
C54 CLKb.n2 VSS 1.13934f
C55 CLKb.t4 VSS 0.86466f
C56 CLKb.n3 VSS 0.71779f
C57 CLKb.n4 VSS 0.65066f
C58 CLKb.n5 VSS 0.17625f
C59 CLKb.n6 VSS 0.49658f
C60 CLKb.n7 VSS 0.27463f
C61 in1.t1 VSS 0.43267f
C62 in1.n0 VSS 0.47192f
C63 in1.n1 VSS 0.21422f
C64 in1.t5 VSS 0.37139f
C65 in1.n2 VSS 0.71507f
C66 in1.t7 VSS 0.15041f
C67 in1.n3 VSS 0.21559f
C68 in1.n4 VSS 0.14156f
C69 in1.n5 VSS 0.50384f
C70 in1.t6 VSS 0.61231f
C71 in2.t5 VSS 0.41325f
C72 in2.n0 VSS 0.93604f
C73 in2.t4 VSS 0.24294f
C74 in2.n1 VSS 0.24352f
C75 in2.n2 VSS 0.11478f
C76 in2.n3 VSS 0.70771f
C77 in2.t7 VSS 0.14063f
C78 in2.n4 VSS 0.23124f
C79 in2.n5 VSS 0.13521f
C80 in2.n6 VSS 0.66873f
C81 in2.t6 VSS 0.68525f
C82 out2.n0 VSS 0.14838f
C83 out2.n1 VSS 0.79448f
C84 out2.t5 VSS 0.13122f
C85 out2.t6 VSS 0.12086f
C86 out2.n2 VSS 0.2592f
C87 out2.n4 VSS 0.25605f
C88 out2.n8 VSS 0.28279f
C89 out2.n9 VSS 0.11168f
C90 out2.n10 VSS 0.43707f
C91 out2.t4 VSS 0.51485f
C92 out2.n11 VSS 0.24394f
C93 out2.t2 VSS 0.15428f
C94 out2.t7 VSS 0.12419f
C95 out2.n12 VSS 0.18939f
C96 out2.t0 VSS 0.17642f
C97 a_828_987.t1 VSS 0.26827f
C98 a_828_987.t2 VSS 0.26934f
C99 a_828_987.n0 VSS 0.76109f
C100 a_828_987.n1 VSS 0.1707f
C101 a_2044_987.t2 VSS 0.27373f
C102 a_2044_987.n0 VSS 0.17349f
C103 a_2044_987.n1 VSS 0.77352f
C104 a_2044_987.t0 VSS 0.27264f
C105 a_2812_987.t2 VSS 0.27476f
C106 a_2812_987.n0 VSS 0.17414f
C107 a_2812_987.n1 VSS 0.77641f
C108 a_2812_987.t0 VSS 0.27367f
C109 a_4028_987.t2 VSS 0.28876f
C110 a_4028_987.t3 VSS 0.28992f
C111 a_4028_987.n0 VSS 0.81924f
C112 a_4028_987.n1 VSS 0.18374f
C113 VDD.n0 VSS 0.60942f
C114 VDD.n1 VSS 0.35628f
C115 VDD.n2 VSS 0.23767f
C116 VDD.n3 VSS 0.21835f
C117 VDD.n36 VSS 0.13172f
C118 VDD.n49 VSS 0.16765f
C119 VDD.n52 VSS 0.16765f
C120 VDD.n55 VSS 0.11975f
C121 VDD.n58 VSS 0.11975f
C122 VDD.n64 VSS 0.11975f
C123 VDD.n66 VSS 0.11975f
C124 VDD.n69 VSS 0.11975f
C125 VDD.n72 VSS 0.11975f
C126 VDD.n75 VSS 0.11975f
C127 VDD.n76 VSS 0.11975f
C128 VDD.t9 VSS 0.16765f
C129 VDD.n79 VSS 0.11975f
C130 VDD.n81 VSS 0.16765f
C131 VDD.n84 VSS 0.11975f
C132 VDD.n86 VSS 0.10777f
C133 VDD.n89 VSS 0.10777f
C134 VDD.n90 VSS 0.16765f
C135 VDD.n91 VSS 0.10777f
C136 VDD.n94 VSS 0.10777f
C137 VDD.n95 VSS 0.16765f
C138 VDD.n96 VSS 0.10777f
C139 VDD.n99 VSS 0.10777f
C140 VDD.n101 VSS 0.11975f
C141 VDD.n104 VSS 0.16765f
C142 VDD.n106 VSS 0.11975f
C143 VDD.t21 VSS 0.16765f
C144 VDD.n109 VSS 0.11975f
C145 VDD.n110 VSS 0.13172f
C146 VDD.t0 VSS 0.16765f
C147 VDD.n113 VSS 0.11975f
C148 VDD.n114 VSS 0.13172f
C149 VDD.t46 VSS 0.16765f
C150 VDD.n117 VSS 0.11975f
C151 VDD.n118 VSS 0.11975f
C152 VDD.n121 VSS 0.10777f
C153 VDD.n122 VSS 0.1437f
C154 VDD.n123 VSS 0.15567f
C155 VDD.n126 VSS 0.10777f
C156 VDD.n127 VSS 0.11975f
C157 VDD.n128 VSS 0.10777f
C158 VDD.n131 VSS 0.15567f
C159 VDD.n132 VSS 0.26644f
C160 VDD.n134 VSS 0.23692f
C161 VDD.n135 VSS 0.23692f
C162 VDD.n140 VSS 0.21854f
C163 CLK.t0 VSS 0.41461f
C164 CLK.n0 VSS 0.10462f
C165 D.t1 VSS 0.12062f
C166 D.t2 VSS 0.10087f
C167 D.n0 VSS 0.28087f
C168 D.t0 VSS 0.63537f
C169 QN.t1 VSS 0.14778f
C170 QN.n1 VSS 0.16936f
C171 QN.t3 VSS 0.44211f
C172 QN.n2 VSS 0.1563f
C173 Q.t1 VSS 0.17437f
C174 Q.n0 VSS 0.10739f
C175 Q.n1 VSS 0.18497f
.ends
