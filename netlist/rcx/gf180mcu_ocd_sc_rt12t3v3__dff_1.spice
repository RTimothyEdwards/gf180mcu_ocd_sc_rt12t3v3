* NGSPICE file created from gf180mcu_ocd_sc_rt12t3v3__dff_1.ext - technology: gf180mcuD

.subckt gf180mcu_ocd_sc_rt12t3v3__dff_1 D CLK Q QN VDD VSS
X0 a_828_987.t2 CLKb.t7 in1.t0 VDD.t14 pfet_03v3 ad=0.5654p pd=3.45u as=0.3341p ps=1.805u w=1.285u l=0.28u
X1 out1 in1.t8 VDD.t45 VDD.t44 pfet_03v3 ad=0.3341p pd=1.805u as=0.5654p ps=3.45u w=1.285u l=0.28u
X2 a_2812_987.t3 out1 VDD.t39 VDD.t38 pfet_03v3 ad=0.3341p pd=1.805u as=0.3341p ps=1.805u w=1.285u l=0.28u
X3 a_4028_987.t3 out2.t7 VDD.t31 VDD.t30 pfet_03v3 ad=0.3341p pd=1.805u as=0.3341p ps=1.805u w=1.285u l=0.28u
X4 CLKN CLK.t2 VDD.t5 VDD.t4 pfet_03v3 ad=0.3341p pd=1.805u as=19.0728p ps=0.12486m w=1.285u l=0.28u
X5 VDD.t16 CLKN CLKb.t1 VDD.t15 pfet_03v3 ad=0.5654p pd=3.45u as=0.3341p ps=1.805u w=1.285u l=0.28u
X6 VDD.t11 D.t2 a_828_987.t0 VDD.t10 pfet_03v3 ad=0.3341p pd=1.805u as=0.5654p ps=3.45u w=1.285u l=0.28u
X7 out2.t2 in2.t7 VDD.t27 VDD.t26 pfet_03v3 ad=0.5654p pd=3.45u as=0.3341p ps=1.805u w=1.285u l=0.28u
X8 in1.t3 CLKN a_945_203r# VSS.t10 nfet_03v3 ad=0.3087p pd=2.01u as=0.52065p ps=3.23u w=1.02u l=0.28u
X9 VDD.t35 out1 a_2044_987.t2 VDD.t34 pfet_03v3 ad=0.3341p pd=1.805u as=0.5654p ps=3.45u w=1.285u l=0.28u
X10 a_2044_987.t1 CLKN in1.t2 VDD.t20 pfet_03v3 ad=0.5654p pd=3.45u as=0.3341p ps=1.805u w=1.285u l=0.28u
X11 VDD.t33 out1 a_2812_987.t2 VDD.t32 pfet_03v3 ad=0.3341p pd=1.805u as=0.5654p ps=3.45u w=1.285u l=0.28u
X12 Q.t2 QN.t5 VDD.t41 VDD.t40 pfet_03v3 ad=0.3341p pd=1.805u as=0.3341p ps=1.805u w=1.285u l=0.28u
X13 QN.t0 out2.t3 VSS.t1 VSS.t0 nfet_03v3 ad=0.3087p pd=2.01u as=2.74232p ps=14.88u w=1.02u l=0.28u
X14 a_2044_987.t3 out1 VDD.t37 VDD.t36 pfet_03v3 ad=0.3341p pd=1.805u as=0.3341p ps=1.805u w=1.285u l=0.28u
X15 in2.t5 CLKb.t3 a_2903_203r# VSS.t15 nfet_03v3 ad=0.3087p pd=2.01u as=0.52065p ps=3.23u w=1.02u l=0.28u
X16 Q.t0 QN.t3 VSS.t23 VSS.t22 nfet_03v3 ad=0.3087p pd=2.01u as=3.08512p ps=16.74u w=1.02u l=0.28u
X17 a_2135_203r# out1 VSS.t19 VSS.t18 nfet_03v3 ad=0.3087p pd=2.01u as=2.74232p ps=14.88u w=1.02u l=0.28u
X18 a_2903_203r# out1 VSS.t21 VSS.t20 nfet_03v3 ad=0.3087p pd=2.01u as=2.74232p ps=14.88u w=1.02u l=0.28u
X19 a_828_987.t1 D.t1 VDD.t13 VDD.t12 pfet_03v3 ad=0.3341p pd=1.805u as=0.3341p ps=1.805u w=1.285u l=0.28u
X20 CLKN CLK.t0 VSS.t5 VSS.t4 nfet_03v3 ad=0.3087p pd=2.01u as=3.08512p ps=16.74u w=1.02u l=0.28u
X21 out1 in1.t6 VSS.t17 VSS.t16 nfet_03v3 ad=0.3087p pd=2.015u as=3.08512p ps=16.74u w=1.02u l=0.28u
X22 VDD.t29 in1.t7 out1 VDD.t28 pfet_03v3 ad=0.5654p pd=3.45u as=0.3341p ps=1.805u w=1.285u l=0.28u
X23 VDD.t43 QN.t4 Q.t1 VDD.t42 pfet_03v3 ad=0.5654p pd=3.45u as=0.3341p ps=1.805u w=1.285u l=0.28u
X24 in2.t0 CLKb.t6 a_4028_987.t1 VDD.t2 pfet_03v3 ad=0.3341p pd=1.805u as=0.3341p ps=1.805u w=1.285u l=0.28u
X25 in2.t2 CLKN a_2812_987.t0 VDD.t21 pfet_03v3 ad=0.3341p pd=1.805u as=0.3341p ps=1.805u w=1.285u l=0.28u
X26 VDD.t7 CLK.t1 CLKN VDD.t6 pfet_03v3 ad=0.3341p pd=1.805u as=0.3341p ps=1.805u w=1.285u l=0.28u
X27 in1.t5 CLKb.t4 a_2135_203r# VSS.t14 nfet_03v3 ad=0.3087p pd=2.01u as=0.52065p ps=3.23u w=1.02u l=0.28u
X28 a_4028_987.t2 CLKb.t5 in2.t1 VDD.t3 pfet_03v3 ad=0.5654p pd=3.45u as=0.3341p ps=1.805u w=1.285u l=0.28u
X29 a_2812_987.t1 CLKN in2.t3 VDD.t22 pfet_03v3 ad=0.5654p pd=3.45u as=0.3341p ps=1.805u w=1.285u l=0.28u
X30 QN.t2 out2.t6 VDD.t47 VDD.t46 pfet_03v3 ad=0.3341p pd=1.805u as=0.5654p ps=3.45u w=1.285u l=0.28u
X31 CLKb.t0 CLKN VDD.t18 VDD.t17 pfet_03v3 ad=0.3341p pd=1.805u as=0.3341p ps=1.805u w=1.285u l=0.28u
X32 CLKb.t2 CLKN VSS.t9 VSS.t8 nfet_03v3 ad=0.3087p pd=2.01u as=3.08512p ps=16.74u w=1.02u l=0.28u
X33 VDD.t9 in2.t8 out2.t0 VDD.t8 pfet_03v3 ad=0.3341p pd=1.805u as=0.5654p ps=3.45u w=1.285u l=0.28u
X34 in1.t1 CLKN a_2044_987.t0 VDD.t19 pfet_03v3 ad=0.3341p pd=1.805u as=0.3341p ps=1.805u w=1.285u l=0.28u
X35 in1.t4 CLKb.t8 a_828_987.t3 VDD.t23 pfet_03v3 ad=0.3341p pd=1.805u as=0.3341p ps=1.805u w=1.285u l=0.28u
X36 VDD.t25 out2.t5 QN.t1 VDD.t24 pfet_03v3 ad=0.3341p pd=1.805u as=0.3341p ps=1.805u w=1.285u l=0.28u
X37 in2.t4 CLKN a_4107_203r# VSS.t11 nfet_03v3 ad=0.3087p pd=2.01u as=0.53235p ps=3.25u w=1.02u l=0.28u
X38 a_945_203r# D.t0 VSS.t7 VSS.t6 nfet_03v3 ad=0.3087p pd=2.01u as=3.08512p ps=16.74u w=1.02u l=0.28u
X39 VDD.t1 out2.t8 a_4028_987.t0 VDD.t0 pfet_03v3 ad=0.3341p pd=1.805u as=0.5654p ps=3.45u w=1.285u l=0.28u
X40 out2.t1 in2.t6 VSS.t13 VSS.t12 nfet_03v3 ad=0.3087p pd=2.015u as=3.08512p ps=16.74u w=1.02u l=0.28u
X41 a_4107_203r# out2.t4 VSS.t3 VSS.t2 nfet_03v3 ad=0.3087p pd=2.01u as=2.74232p ps=14.88u w=1.02u l=0.28u
R0 Q.n6 Q.t0 50.9005
R1 Q.n2 Q.n7 32.5888
R2 Q.n7 Q.n6 16.9387
R3 Q.n6 Q.n0 11.9058
R4 Q Q.n3 6.5781
R5 Q.n3 Q.n0 3.31861
R6 Q.n7 Q.n4 3.6505
R7 Q Q.n5 2.92847
R8 Q.n2 Q.n0 0.0474974
R9 Q.n1 Q.t0 0.459182
R10 Q.n1 Q.n4 0.825727
R11 Q.n5 Q.t2 1.41684
R12 Q.n5 Q.t1 1.41684
R13 Q.n3 Q.t0 5.88322
R14 Q.n3 Q.n4 1.7588
R15 Q.n2 Q.n1 1.57306
R16 QN.n7 QN.t0 50.9005
R17 QN.n6 QN.t4 41.7438
R18 QN.n6 QN.t5 38.0938
R19 QN.n2 QN.n8 32.5888
R20 QN.n8 QN.n7 16.9387
R21 QN.n7 QN.n0 11.9058
R22 QN QN.n3 6.68456
R23 QN.n3 QN.n0 3.31861
R24 QN QN.n6 4.22746
R25 QN.n8 QN.n4 3.6505
R26 QN QN.t3 6.4561
R27 QN.n2 QN.n0 0.0474974
R28 QN.n1 QN.t0 0.459182
R29 QN.n1 QN.n4 0.825727
R30 QN.n5 QN.t2 1.41684
R31 QN.n5 QN.t1 1.41684
R32 QN.n3 QN.t0 5.88322
R33 QN QN.n5 3.9218
R34 QN.n3 QN.n4 1.7588
R35 QN.n2 QN.n1 1.57306
R36 D.n0 D.t1 31.3586
R37 D.n0 D.t2 23.4503
R38 D D.n0 13.8634
R39 D D.t0 6.75352
R40 CLK.n0 CLK.t1 40.1505
R41 CLK.n0 CLK.t2 19.2934
R42 CLK CLK.n0 15.7625
R43 CLK CLK.t0 7.00022
R44 VDD.n135 VDD.n134 796.235
R45 VDD.n140 VDD.n36 137.088
R46 VDD.t6 VDD.n76 137.088
R47 VDD.t6 VDD.n75 137.088
R48 VDD.n81 VDD.n80 137.088
R49 VDD.n81 VDD.n72 137.088
R50 VDD.n86 VDD.n85 137.088
R51 VDD.n90 VDD.n89 137.088
R52 VDD.n91 VDD.n90 137.088
R53 VDD.n95 VDD.n94 137.088
R54 VDD.n96 VDD.n95 137.088
R55 VDD.n100 VDD.n99 137.088
R56 VDD.n104 VDD.n58 137.088
R57 VDD.n105 VDD.n104 137.088
R58 VDD.t21 VDD.n55 137.088
R59 VDD.n109 VDD.t21 137.088
R60 VDD.n110 VDD.n52 137.088
R61 VDD.t8 VDD.n52 137.088
R62 VDD.n113 VDD.t8 137.088
R63 VDD.n114 VDD.n49 137.088
R64 VDD.t0 VDD.n49 137.088
R65 VDD.n117 VDD.t0 137.088
R66 VDD.n121 VDD.n46 137.088
R67 VDD.n123 VDD.n122 137.088
R68 VDD.n126 VDD.n43 137.088
R69 VDD.n128 VDD.n42 137.088
R70 VDD.n132 VDD.n131 137.088
R71 VDD.t15 VDD.n79 117.504
R72 VDD.t12 VDD.n84 117.504
R73 VDD.n101 VDD.t19 117.504
R74 VDD.n106 VDD.t32 117.504
R75 VDD.n118 VDD.t2 117.504
R76 VDD.n123 VDD.t46 117.504
R77 VDD.n131 VDD.t42 117.504
R78 VDD.t23 VDD.n69 97.9197
R79 VDD.n69 VDD.t14 97.9197
R80 VDD.t44 VDD.n66 97.9197
R81 VDD.n66 VDD.t28 97.9197
R82 VDD.t34 VDD.n64 97.9197
R83 VDD.n64 VDD.t36 97.9197
R84 VDD.n122 VDD.t3 97.9197
R85 VDD.n127 VDD.t24 97.9197
R86 VDD.t40 VDD.n127 97.9197
R87 VDD.t4 VDD.n36 78.3359
R88 VDD.n79 VDD.t17 78.3359
R89 VDD.n84 VDD.t10 78.3359
R90 VDD.n101 VDD.t20 78.3359
R91 VDD.n106 VDD.t38 78.3359
R92 VDD.n110 VDD.t22 78.3359
R93 VDD.n114 VDD.t26 78.3359
R94 VDD.n118 VDD.t30 78.3359
R95 VDD.n76 VDD.t4 58.752
R96 VDD.n75 VDD.t17 58.752
R97 VDD.n72 VDD.t10 58.752
R98 VDD.t20 VDD.n58 58.752
R99 VDD.t38 VDD.n55 58.752
R100 VDD.t22 VDD.n109 58.752
R101 VDD.t26 VDD.n113 58.752
R102 VDD.t30 VDD.n117 58.752
R103 VDD.n86 VDD.t23 39.1682
R104 VDD.n89 VDD.t14 39.1682
R105 VDD.n91 VDD.t44 39.1682
R106 VDD.n94 VDD.t28 39.1682
R107 VDD.n96 VDD.t34 39.1682
R108 VDD.n99 VDD.t36 39.1682
R109 VDD.t3 VDD.n121 39.1682
R110 VDD.t24 VDD.n126 39.1682
R111 VDD.n128 VDD.t40 39.1682
R112 VDD.n80 VDD.t15 19.5843
R113 VDD.n85 VDD.t12 19.5843
R114 VDD.t19 VDD.n100 19.5843
R115 VDD.t32 VDD.n105 19.5843
R116 VDD.t2 VDD.n46 19.5843
R117 VDD.t46 VDD.n43 19.5843
R118 VDD.n42 VDD.t42 19.5843
R119 VDD.n6 VDD.n133 5.514
R120 VDD.n37 VDD.n7 4.93411
R121 VDD.n141 VDD.n34 9.8005
R122 VDD.n74 VDD.n34 9.8005
R123 VDD.n77 VDD.n74 9.8005
R124 VDD.n77 VDD.n29 2.75725
R125 VDD.n78 VDD.n33 9.8005
R126 VDD.n78 VDD.n71 9.8005
R127 VDD.n82 VDD.n32 2.75725
R128 VDD.n82 VDD.n9 9.8005
R129 VDD.n83 VDD.n9 9.8005
R130 VDD.n26 VDD.n68 2.75725
R131 VDD.n87 VDD.n68 9.8005
R132 VDD.n87 VDD.n67 9.8005
R133 VDD.n88 VDD.n10 2.75725
R134 VDD.n88 VDD.n65 9.8005
R135 VDD.n92 VDD.n31 2.75725
R136 VDD.n92 VDD.n11 9.8005
R137 VDD.n93 VDD.n11 9.8005
R138 VDD.n30 VDD.n63 2.75725
R139 VDD.n97 VDD.n63 9.8005
R140 VDD.n97 VDD.n61 9.8005
R141 VDD.n98 VDD.n12 2.75725
R142 VDD.n98 VDD.n60 9.8005
R143 VDD.n102 VDD.n13 2.75725
R144 VDD.n102 VDD.n59 9.8005
R145 VDD.n103 VDD.n14 2.75725
R146 VDD.n103 VDD.n57 9.8005
R147 VDD.n107 VDD.n25 2.75725
R148 VDD.n107 VDD.n15 9.8005
R149 VDD.n108 VDD.n15 9.8005
R150 VDD.n16 VDD.n54 2.75725
R151 VDD.n111 VDD.n54 9.8005
R152 VDD.n18 VDD.n17 2.75725
R153 VDD.n112 VDD.n17 9.8005
R154 VDD.n28 VDD.n51 2.75725
R155 VDD.n115 VDD.n51 9.8005
R156 VDD.n20 VDD.n19 2.75725
R157 VDD.n116 VDD.n19 9.8005
R158 VDD.n27 VDD.n48 2.75725
R159 VDD.n119 VDD.n48 9.8005
R160 VDD.n119 VDD.n47 9.8005
R161 VDD.n120 VDD.n21 2.75725
R162 VDD.n120 VDD.n45 9.8005
R163 VDD.n124 VDD.n45 9.8005
R164 VDD.n124 VDD.n24 2.75725
R165 VDD.n125 VDD.n44 9.8005
R166 VDD.n22 VDD.n41 2.75725
R167 VDD.n129 VDD.n41 9.8005
R168 VDD.n129 VDD.n39 9.8005
R169 VDD.n23 VDD.n39 2.75725
R170 VDD.n130 VDD.n8 9.8005
R171 VDD.n138 VDD.n4 7.02237
R172 VDD.n134 VDD.n2 6.51963
R173 VDD.n141 VDD.n35 6.388
R174 VDD.n141 VDD.n140 6.3005
R175 VDD VDD.n141 6.3005
R176 VDD.n36 VDD.n34 6.3005
R177 VDD VDD.n34 6.3005
R178 VDD.n76 VDD.n74 6.3005
R179 VDD.n74 VDD 6.3005
R180 VDD.n77 VDD.t6 6.3005
R181 VDD VDD.n29 1.77287
R182 VDD.n75 VDD.n33 6.3005
R183 VDD.n29 VDD.n33 2.75725
R184 VDD.n79 VDD.n78 6.3005
R185 VDD.n78 VDD.n3 6.3005
R186 VDD.n80 VDD.n71 6.3005
R187 VDD.n32 VDD.n71 2.75725
R188 VDD.n82 VDD.n81 6.3005
R189 VDD.n3 VDD.n32 1.77287
R190 VDD.n72 VDD.n9 6.3005
R191 VDD.n3 VDD.n9 6.3005
R192 VDD.n84 VDD.n83 6.3005
R193 VDD.n83 VDD.n26 2.75725
R194 VDD.n85 VDD.n68 6.3005
R195 VDD.n26 VDD.n3 1.77287
R196 VDD.n87 VDD.n86 6.3005
R197 VDD.n3 VDD.n87 6.3005
R198 VDD.n69 VDD.n67 6.3005
R199 VDD.n10 VDD.n67 2.75725
R200 VDD.n89 VDD.n88 6.3005
R201 VDD.n10 VDD.n0 1.77287
R202 VDD.n90 VDD.n65 6.3005
R203 VDD.n31 VDD.n65 2.75725
R204 VDD.n92 VDD.n91 6.3005
R205 VDD.n0 VDD.n31 1.77287
R206 VDD.n66 VDD.n11 6.3005
R207 VDD.n0 VDD.n11 6.3005
R208 VDD.n94 VDD.n93 6.3005
R209 VDD.n93 VDD.n30 2.75725
R210 VDD.n95 VDD.n63 6.3005
R211 VDD.n30 VDD.n0 1.77287
R212 VDD.n97 VDD.n96 6.3005
R213 VDD.n0 VDD.n97 6.3005
R214 VDD.n64 VDD.n61 6.3005
R215 VDD.n12 VDD.n61 2.75725
R216 VDD.n99 VDD.n98 6.3005
R217 VDD.n12 VDD.n0 1.77287
R218 VDD.n100 VDD.n60 6.3005
R219 VDD.n60 VDD.n13 2.75725
R220 VDD.n102 VDD.n101 6.3005
R221 VDD.n0 VDD.n13 1.77287
R222 VDD.n59 VDD.n58 6.3005
R223 VDD.n14 VDD.n59 2.75725
R224 VDD.n104 VDD.n103 6.3005
R225 VDD.n14 VDD.n0 1.77287
R226 VDD.n105 VDD.n57 6.3005
R227 VDD.n25 VDD.n57 2.75725
R228 VDD.n107 VDD.n106 6.3005
R229 VDD.n0 VDD.n25 1.77287
R230 VDD.n15 VDD.n55 6.3005
R231 VDD.n0 VDD.n15 6.3005
R232 VDD.t21 VDD.n108 6.3005
R233 VDD.n108 VDD.n16 2.75725
R234 VDD.n109 VDD.n54 6.3005
R235 VDD.n16 VDD.n0 1.77287
R236 VDD.n111 VDD.n110 6.3005
R237 VDD.n18 VDD.n111 2.75725
R238 VDD.n17 VDD.n52 6.3005
R239 VDD.n0 VDD.n18 1.77287
R240 VDD.t8 VDD.n112 6.3005
R241 VDD.n112 VDD.n28 2.75725
R242 VDD.n113 VDD.n51 6.3005
R243 VDD.n28 VDD.n1 1.77287
R244 VDD.n115 VDD.n114 6.3005
R245 VDD.n20 VDD.n115 2.75725
R246 VDD.n19 VDD.n49 6.3005
R247 VDD.n1 VDD.n20 1.77287
R248 VDD.t0 VDD.n116 6.3005
R249 VDD.n116 VDD.n27 2.75725
R250 VDD.n117 VDD.n48 6.3005
R251 VDD.n27 VDD.n1 1.77287
R252 VDD.n119 VDD.n118 6.3005
R253 VDD.n1 VDD.n119 6.3005
R254 VDD.n47 VDD.n46 6.3005
R255 VDD.n21 VDD.n47 2.75725
R256 VDD.n121 VDD.n120 6.3005
R257 VDD.n21 VDD.n1 1.77287
R258 VDD.n122 VDD.n45 6.3005
R259 VDD.n45 VDD.n1 6.3005
R260 VDD.n124 VDD.n123 6.3005
R261 VDD.n1 VDD.n24 1.77287
R262 VDD.n44 VDD.n43 6.3005
R263 VDD.n24 VDD.n44 2.75725
R264 VDD.n126 VDD.n125 6.3005
R265 VDD.n125 VDD.n22 2.75725
R266 VDD.n127 VDD.n41 6.3005
R267 VDD.n22 VDD.n2 1.77287
R268 VDD.n129 VDD.n128 6.3005
R269 VDD.n2 VDD.n129 6.3005
R270 VDD.n42 VDD.n39 6.3005
R271 VDD.n2 VDD.n23 1.77287
R272 VDD.n131 VDD.n130 6.3005
R273 VDD.n130 VDD.n23 2.75725
R274 VDD.n2 VDD.n8 6.3005
R275 VDD.n35 VDD 6.3005
R276 VDD.n4 VDD.n5 0.784727
R277 VDD VDD.n138 6.3005
R278 VDD.n140 VDD.n135 6.3005
R279 VDD.n6 VDD.n2 1.77287
R280 VDD.n6 VDD.n38 5.514
R281 VDD.n2 VDD.n7 1.77287
R282 VDD.n1 VDD.n50 5.42746
R283 VDD.n1 VDD.n53 5.42746
R284 VDD.n0 VDD.n56 5.42746
R285 VDD.n3 VDD.n70 5.42746
R286 VDD.n0 VDD.n62 5.42746
R287 VDD.n137 VDD.n136 5.4131
R288 VDD.n0 VDD.t29 4.32989
R289 VDD.n0 VDD.t45 4.32989
R290 VDD.n1 VDD.t47 4.32793
R291 VDD.n2 VDD.t43 4.32597
R292 VDD.n3 VDD.t16 4.32597
R293 VDD VDD.n73 2.91159
R294 VDD.n5 VDD 1.74437
R295 VDD.n2 VDD.n40 2.91159
R296 VDD.n137 VDD.n135 2.82549
R297 VDD.n134 VDD.n133 2.75725
R298 VDD.n7 VDD.n38 5.514
R299 VDD.n138 VDD.n136 2.68305
R300 VDD.n139 VDD.n35 2.32205
R301 VDD.n139 VDD.n4 2.32205
R302 VDD.n8 VDD.n37 2.17736
R303 VDD.n132 VDD.n37 2.06282
R304 VDD VDD.n137 2.03587
R305 VDD.n140 VDD.n139 1.99047
R306 VDD.n1 VDD.n0 1.8485
R307 VDD.n140 VDD.n136 1.80997
R308 VDD.n133 VDD.n132 1.77287
R309 VDD.n132 VDD.n38 1.77287
R310 VDD.n50 VDD.t1 1.41684
R311 VDD.n50 VDD.t31 1.41684
R312 VDD.n53 VDD.t9 1.41684
R313 VDD.n53 VDD.t27 1.41684
R314 VDD.n56 VDD.t33 1.41684
R315 VDD.n56 VDD.t39 1.41684
R316 VDD.n70 VDD.t11 1.41684
R317 VDD.n70 VDD.t13 1.41684
R318 VDD.n73 VDD.t7 1.41684
R319 VDD.n73 VDD.t18 1.41684
R320 VDD.n5 VDD.t5 1.77948
R321 VDD.n40 VDD.t25 1.41684
R322 VDD.n40 VDD.t41 1.41684
R323 VDD.n62 VDD.t35 1.41684
R324 VDD.n62 VDD.t37 1.41684
R325 VDD.n2 VDD.n1 1.34763
R326 VDD.n0 VDD.n3 1.1765
R327 VDD.n3 VDD 1.1285
R328 VSS.n151 VSS.n150 897.538
R329 VSS.n154 VSS.n153 513.399
R330 VSS.n87 VSS.n86 513.399
R331 VSS.n87 VSS.n85 513.399
R332 VSS.n91 VSS.n90 513.399
R333 VSS.n91 VSS.n82 513.399
R334 VSS.n94 VSS.n82 513.399
R335 VSS.n95 VSS.n80 513.399
R336 VSS.n97 VSS.n80 513.399
R337 VSS.n99 VSS.n98 513.399
R338 VSS.n99 VSS.n77 513.399
R339 VSS.n102 VSS.n77 513.399
R340 VSS.n104 VSS.n103 513.399
R341 VSS.n104 VSS.n76 513.399
R342 VSS.n108 VSS.n107 513.399
R343 VSS.n109 VSS.n108 513.399
R344 VSS.n109 VSS.n73 513.399
R345 VSS.n113 VSS.n112 513.399
R346 VSS.n114 VSS.n113 513.399
R347 VSS.n118 VSS.n69 513.399
R348 VSS.n119 VSS.n118 513.399
R349 VSS.n120 VSS.n119 513.399
R350 VSS.n123 VSS.n66 513.399
R351 VSS.n124 VSS.n123 513.399
R352 VSS.n125 VSS.n64 513.399
R353 VSS.n128 VSS.n64 513.399
R354 VSS.n129 VSS.n128 513.399
R355 VSS.n130 VSS.n62 513.399
R356 VSS.n133 VSS.n62 513.399
R357 VSS.n134 VSS.n133 513.399
R358 VSS.n135 VSS.n58 513.399
R359 VSS.n138 VSS.n58 513.399
R360 VSS.n140 VSS.n139 513.399
R361 VSS.n140 VSS.n57 513.399
R362 VSS.n144 VSS.n143 513.399
R363 VSS.n145 VSS.n144 513.399
R364 VSS.n145 VSS.n54 513.399
R365 VSS.n135 VSS.t11 495.063
R366 VSS.n76 VSS.t18 490.481
R367 VSS.n103 VSS.t16 458.392
R368 VSS.n114 VSS.t20 417.137
R369 VSS.t10 VSS.n97 412.553
R370 VSS.n85 VSS.t8 380.466
R371 VSS.t15 VSS.n66 366.714
R372 VSS.n95 VSS.t6 343.795
R373 VSS.n139 VSS.t0 343.795
R374 VSS.t12 VSS.n124 339.211
R375 VSS.n57 VSS.t22 325.459
R376 VSS.n112 VSS.t14 293.372
R377 VSS.n86 VSS.t4 288.788
R378 VSS.t2 VSS.n129 288.788
R379 VSS.n154 VSS.t4 224.613
R380 VSS.n130 VSS.t2 224.613
R381 VSS.n73 VSS.t14 220.029
R382 VSS.n143 VSS.t22 187.941
R383 VSS.n125 VSS.t12 174.19
R384 VSS.t6 VSS.n94 169.606
R385 VSS.t0 VSS.n138 169.606
R386 VSS.n120 VSS.t15 146.685
R387 VSS.n90 VSS.t8 132.935
R388 VSS.n98 VSS.t10 100.847
R389 VSS.t20 VSS.n69 96.2628
R390 VSS.t16 VSS.n102 55.0075
R391 VSS.n107 VSS.t18 22.9201
R392 VSS.t11 VSS.n134 18.3362
R393 VSS.n146 VSS.n36 2.66071
R394 VSS.n132 VSS.n61 10.8894
R395 VSS.n136 VSS.n35 2.66071
R396 VSS.n136 VSS.n60 10.8894
R397 VSS.n127 VSS.n50 10.8894
R398 VSS.n121 VSS.n68 10.8894
R399 VSS.n121 VSS.n67 10.8894
R400 VSS.n122 VSS.n34 2.66071
R401 VSS.n122 VSS.n48 10.8894
R402 VSS.n110 VSS.n72 10.8894
R403 VSS.n111 VSS.n32 2.66071
R404 VSS.n111 VSS.n71 10.8894
R405 VSS.n115 VSS.n33 2.66071
R406 VSS.n105 VSS.n75 10.8894
R407 VSS.n29 VSS.n79 2.66071
R408 VSS.n100 VSS.n79 10.8894
R409 VSS.n31 VSS.n30 2.66071
R410 VSS.n155 VSS.n53 10.8894
R411 VSS.n141 VSS.n49 10.8507
R412 VSS.n96 VSS.n52 10.8507
R413 VSS.n137 VSS.n38 2.6499
R414 VSS.n93 VSS.n43 10.7992
R415 VSS.n88 VSS.n40 2.63743
R416 VSS.n26 VSS.n12 2.61532
R417 VSS.n101 VSS.n30 10.4771
R418 VSS.n146 VSS.n51 10.4126
R419 VSS.n27 VSS.n14 2.59768
R420 VSS.n45 VSS.n75 2.58307
R421 VSS.n44 VSS.n43 2.58307
R422 VSS.n46 VSS.n68 2.56994
R423 VSS.n116 VSS.n115 10.0519
R424 VSS.n110 VSS.n28 2.54328
R425 VSS.n89 VSS.n47 9.94879
R426 VSS.n126 VSS.n37 2.52805
R427 VSS.n142 VSS.n41 2.52293
R428 VSS.n39 VSS.n20 2.51436
R429 VSS.n131 VSS.n42 2.50919
R430 VSS.n137 VSS.n5 9.27761
R431 VSS.n93 VSS.n4 9.27761
R432 VSS.n88 VSS.n0 8.60291
R433 VSS.n13 VSS.n12 7.42219
R434 VSS.n25 VSS.n53 7.38939
R435 VSS.n147 VSS.n55 7.38939
R436 VSS.n101 VSS.n22 2.40308
R437 VSS.n11 VSS.n51 2.32493
R438 VSS.n15 VSS.n14 6.49448
R439 VSS.n106 VSS.n19 5.73544
R440 VSS.n92 VSS.n24 5.73544
R441 VSS VSS.n151 5.41963
R442 VSS.n150 VSS.n1 5.41963
R443 VSS.n155 VSS.n154 5.2005
R444 VSS VSS.n155 3.00607
R445 VSS.n153 VSS.n53 5.2005
R446 VSS.n53 VSS 5.2005
R447 VSS.n88 VSS.n87 5.2005
R448 VSS VSS.n40 1.28278
R449 VSS.n86 VSS.n0 5.2005
R450 VSS.n85 VSS.n47 5.2005
R451 VSS.n40 VSS.n47 2.63743
R452 VSS.n92 VSS.n91 5.2005
R453 VSS.n44 VSS.n92 2.58307
R454 VSS.n90 VSS.n89 5.2005
R455 VSS.n23 VSS 1.35911
R456 VSS.n43 VSS.n82 5.2005
R457 VSS VSS.n44 1.30997
R458 VSS.n4 VSS.n95 5.2005
R459 VSS.n94 VSS.n93 5.2005
R460 VSS.n93 VSS 5.2005
R461 VSS.n30 VSS.n77 5.2005
R462 VSS VSS.n31 1.27115
R463 VSS.n100 VSS.n99 5.2005
R464 VSS.n31 VSS.n100 2.66071
R465 VSS.n98 VSS.n79 5.2005
R466 VSS.n29 VSS 1.27115
R467 VSS.n97 VSS.n96 5.2005
R468 VSS.n96 VSS.n29 2.66071
R469 VSS.n52 VSS.n80 5.2005
R470 VSS.n103 VSS.n20 5.2005
R471 VSS VSS.n39 1.34432
R472 VSS.n102 VSS.n101 5.2005
R473 VSS.n22 VSS 1.0565
R474 VSS.n76 VSS.n75 5.2005
R475 VSS.n2 VSS.n45 1.30997
R476 VSS.n105 VSS.n104 5.2005
R477 VSS.n39 VSS.n105 2.51436
R478 VSS.n108 VSS.n18 5.2005
R479 VSS.n28 VSS.n18 2.54328
R480 VSS.n107 VSS.n106 5.2005
R481 VSS.n106 VSS.n45 2.58307
R482 VSS.n115 VSS.n114 5.2005
R483 VSS.n33 VSS.n2 1.27115
R484 VSS.n113 VSS.n71 5.2005
R485 VSS.n33 VSS.n71 2.66071
R486 VSS.n112 VSS.n111 5.2005
R487 VSS.n32 VSS.n2 1.27115
R488 VSS.n73 VSS.n72 5.2005
R489 VSS.n32 VSS.n72 2.66071
R490 VSS.n110 VSS.n109 5.2005
R491 VSS.n2 VSS.n28 1.32986
R492 VSS.n118 VSS.n117 5.2005
R493 VSS.n117 VSS.n46 2.56994
R494 VSS.n116 VSS.n69 5.2005
R495 VSS.n2 VSS.n17 1.28716
R496 VSS.n124 VSS.n48 5.2005
R497 VSS.n37 VSS.n48 2.52805
R498 VSS.n123 VSS.n122 5.2005
R499 VSS.n34 VSS.n2 1.27115
R500 VSS.n67 VSS.n66 5.2005
R501 VSS.n34 VSS.n67 2.66071
R502 VSS.n121 VSS.n120 5.2005
R503 VSS.n2 VSS.n121 5.2005
R504 VSS.n119 VSS.n68 5.2005
R505 VSS.n46 VSS.n2 1.31653
R506 VSS.n14 VSS.n64 5.2005
R507 VSS.n2 VSS.n27 1.30266
R508 VSS.n126 VSS.n125 5.2005
R509 VSS.n37 VSS.n2 1.33747
R510 VSS.n129 VSS.n50 5.2005
R511 VSS.n42 VSS.n50 2.50919
R512 VSS.n128 VSS.n127 5.2005
R513 VSS.n127 VSS.n27 2.59768
R514 VSS.n12 VSS.n62 5.2005
R515 VSS.n2 VSS.n26 1.29384
R516 VSS.n131 VSS.n130 5.2005
R517 VSS.n42 VSS.n2 1.3469
R518 VSS.n60 VSS.n58 5.2005
R519 VSS.n38 VSS.n60 2.6499
R520 VSS.n136 VSS.n135 5.2005
R521 VSS.n1 VSS.n35 1.27115
R522 VSS.n134 VSS.n61 5.2005
R523 VSS.n61 VSS.n35 2.66071
R524 VSS.n133 VSS.n132 5.2005
R525 VSS.n132 VSS.n26 2.61532
R526 VSS.n139 VSS.n5 5.2005
R527 VSS.n138 VSS.n137 5.2005
R528 VSS.n38 VSS.n1 1.27655
R529 VSS.n57 VSS.n49 5.2005
R530 VSS.n41 VSS.n49 2.52293
R531 VSS.n141 VSS.n140 5.2005
R532 VSS.n144 VSS.n51 5.2005
R533 VSS.n1 VSS.n11 1.08598
R534 VSS.n143 VSS.n142 5.2005
R535 VSS.n41 VSS.n1 1.34003
R536 VSS.n55 VSS.n54 5.2005
R537 VSS.n36 VSS.n55 2.66071
R538 VSS.n146 VSS.n145 5.2005
R539 VSS.n1 VSS.n36 1.27115
R540 VSS.n9 VSS.n1 1.27115
R541 VSS.n148 VSS.n9 5.32092
R542 VSS.n147 VSS.n1 5.2005
R543 VSS VSS.n25 5.2005
R544 VSS VSS.n8 1.27115
R545 VSS.n117 VSS.n16 5.06074
R546 VSS.n10 VSS.t23 4.4105
R547 VSS.n5 VSS.t1 4.4105
R548 VSS.n13 VSS.t3 4.4105
R549 VSS.n15 VSS.t13 4.4105
R550 VSS.n16 VSS.t21 4.4105
R551 VSS.n19 VSS.t19 4.4105
R552 VSS.n21 VSS.t17 4.4105
R553 VSS.n4 VSS.t7 4.4105
R554 VSS.n24 VSS.t9 4.4105
R555 VSS.n0 VSS.t5 4.4105
R556 VSS.n116 VSS.n17 1.79164
R557 VSS.n1 VSS 4.0535
R558 VSS.n1 VSS 3.776
R559 VSS.n19 VSS.n18 3.71134
R560 VSS.n89 VSS.n23 1.60092
R561 VSS.n2 VSS 3.2075
R562 VSS.n24 VSS.n23 0.970182
R563 VSS.n4 VSS.n3 1.21585
R564 VSS.n22 VSS.n21 1.45611
R565 VSS.n2 VSS.n19 3.1505
R566 VSS.n17 VSS.n16 1.08572
R567 VSS.n2 VSS.n15 3.1505
R568 VSS.n2 VSS.n13 3.1505
R569 VSS.n6 VSS.n5 1.21585
R570 VSS.n11 VSS.n10 1.40876
R571 VSS.n24 VSS.n83 2.9615
R572 VSS.n19 VSS.n74 2.9615
R573 VSS.n16 VSS.n70 2.9615
R574 VSS.n15 VSS.n65 2.9615
R575 VSS.n15 VSS.n126 2.95231
R576 VSS.n142 VSS.n10 2.8883
R577 VSS.n2 VSS 2.87975
R578 VSS.n10 VSS.n56 2.7725
R579 VSS.n5 VSS.n59 2.7725
R580 VSS.n13 VSS.n63 2.7725
R581 VSS.n21 VSS.n78 2.7725
R582 VSS.n4 VSS.n81 2.7725
R583 VSS.n0 VSS.n84 2.7725
R584 VSS.n151 VSS.n7 2.66071
R585 VSS.n150 VSS.n149 2.66071
R586 VSS.n152 VSS.n25 2.66071
R587 VSS.n152 VSS.n8 5.32092
R588 VSS.n8 VSS.n7 5.32092
R589 VSS.n148 VSS.n147 2.66071
R590 VSS.n149 VSS.n9 5.32092
R591 VSS.n141 VSS.n6 3.00215
R592 VSS.n3 VSS.n52 3.00215
R593 VSS.n1 VSS 2.63542
R594 VSS VSS.n0 2.48229
R595 VSS.n21 VSS.n20 2.46661
R596 VSS.n1 VSS 2.44728
R597 VSS.n2 VSS 2.3045
R598 VSS.n13 VSS.n131 2.2136
R599 VSS.n2 VSS 2.06186
R600 VSS.n2 VSS 1.83965
R601 VSS.n2 VSS 1.7285
R602 VSS.n2 VSS 1.60083
R603 VSS.n2 VSS 1.44965
R604 VSS.n1 VSS.n6 1.32889
R605 VSS.n149 VSS.n54 1.27115
R606 VSS.n148 VSS.n54 1.27115
R607 VSS.n153 VSS.n152 1.27115
R608 VSS.n153 VSS.n7 1.27115
R609 VSS VSS.n3 1.20945
R610 VSS.n2 VSS 1.05914
R611 VSS.n2 VSS.n1 1.01339
R612 a_4028_987.t0 a_4028_987.n1 4.91293
R613 a_4028_987.n1 a_4028_987.t2 4.89923
R614 a_4028_987.n1 a_4028_987.n0 2.6005
R615 a_4028_987.n0 a_4028_987.t1 1.41684
R616 a_4028_987.n0 a_4028_987.t3 1.41684
R617 a_2812_987.t2 a_2812_987.n1 4.91293
R618 a_2812_987.n1 a_2812_987.t1 4.89923
R619 a_2812_987.n1 a_2812_987.n0 2.6005
R620 a_2812_987.n0 a_2812_987.t0 1.41684
R621 a_2812_987.n0 a_2812_987.t3 1.41684
R622 a_2044_987.t2 a_2044_987.n1 4.91293
R623 a_2044_987.n1 a_2044_987.t1 4.89923
R624 a_2044_987.n1 a_2044_987.n0 2.6005
R625 a_2044_987.n0 a_2044_987.t0 1.41684
R626 a_2044_987.n0 a_2044_987.t3 1.41684
R627 a_828_987.n0 a_828_987.t0 4.91293
R628 a_828_987.n0 a_828_987.t2 4.89923
R629 a_828_987.n1 a_828_987.n0 2.6005
R630 a_828_987.n1 a_828_987.t3 1.41684
R631 a_828_987.t1 a_828_987.n1 1.41684
R632 out2.n7 out2.n4 149.65
R633 out2.n1 out2.t5 42.3521
R634 out2.n10 out2.n9 39.0274
R635 out2.n13 out2.t7 38.5572
R636 out2.n1 out2.t6 37.4854
R637 out2.n9 out2.n8 34.1993
R638 out2.n13 out2.t8 19.2934
R639 out2 out2.t4 14.0382
R640 out2 out2.n0 10.3473
R641 out2.n5 out2.n4 10.0787
R642 out2.n0 out2.n13 9.14178
R643 out2.n3 out2.n2 8.30246
R644 out2.n5 out2.n3 5.85149
R645 out2.n11 out2.n1 4.85354
R646 out2.n0 out2.t0 4.68989
R647 out2.n8 out2.n4 4.27703
R648 out2.n11 out2.n10 4.16093
R649 out2.n12 out2.t1 3.29406
R650 out2.n6 out2.n2 2.73148
R651 out2.t3 out2.n7 2.42671
R652 out2.n9 out2.n3 2.23725
R653 out2 out2.t1 7.34144
R654 out2.n6 out2.n5 1.58769
R655 out2.n7 out2.n6 1.29467
R656 out2.n10 out2.n2 1.19234
R657 out2.n8 out2.t3 1.11195
R658 out2.n0 out2.t2 4.1649
R659 out2 out2.n11 1.96415
R660 in2.t5 in2.n24 111.456
R661 in2.n12 in2.n8 88.7005
R662 in2.n26 in2.n25 88.7005
R663 in2.n15 in2.n5 85.0505
R664 in2.t5 in2.n3 1.69161
R665 in2.n8 in2.n5 47.2505
R666 in2.n16 in2.n15 47.2505
R667 in2.n25 in2.n22 47.2505
R668 in2.n19 in2.t7 37.891
R669 in2.n19 in2.t8 19.2934
R670 in2.n2 in2.n28 5.12143
R671 in2.n9 in2.n7 17.0759
R672 in2.n12 in2.n11 15.5491
R673 in2.n28 in2.n26 15.5491
R674 in2.n18 in2.n17 11.3038
R675 in2.n13 in2.n12 11.0809
R676 in2.n26 in2.n24 11.0809
R677 in2.n18 in2.n4 10.7372
R678 in2.n16 in2.n14 10.4505
R679 in2.n0 in2.n21 10.3205
R680 in2.n14 in2.n7 8.32713
R681 in2.n21 in2.n19 8.0394
R682 in2.n17 in2.t4 6.40912
R683 in2.n29 in2.t5 6.40912
R684 in2.n0 in2.n29 6.3005
R685 in2.n14 in2.n13 5.73172
R686 in2.n21 in2.n20 5.2005
R687 in2 in2.n18 5.12779
R688 in2.n9 in2.n1 5.06743
R689 in2.n13 in2.n6 3.1505
R690 in2.n15 in2.n6 3.1505
R691 in2.t4 in2.n16 3.1505
R692 in2.n24 in2.n23 3.1505
R693 in2.n22 in2.n3 87.9163
R694 in2.n0 in2.t6 6.51843
R695 in2.t4 in2.n1 0.206238
R696 in2.t5 in2.n2 0.161734
R697 in2.t4 in2.n7 2.1221
R698 in2.n3 in2.n23 0.106663
R699 in2.n8 in2.n6 1.7505
R700 in2.n25 in2.n23 1.7505
R701 in2.n17 in2.n5 1.62981
R702 in2.n29 in2.n22 1.62981
R703 in2.n1 in2.n5 3.88957
R704 in2.n2 in2.n22 3.93332
R705 in2.t4 in2.n6 1.85912
R706 in2 in2.n0 1.69192
R707 in2.n20 in2.t2 1.41684
R708 in2.n20 in2.t3 1.41684
R709 in2.n4 in2.t0 1.41684
R710 in2.n4 in2.t1 1.41684
R711 in2.n11 in2.n10 1.32827
R712 in2.n28 in2.n27 1.32827
R713 in2.n11 in2.n9 1.16236
R714 in1.t3 in1.n22 111.456
R715 in1.t5 in1.n2 1.68642
R716 in1.t5 in1.n1 0.152381
R717 in1.n24 in1.n23 88.7005
R718 in1.n8 in1.n7 85.0505
R719 in1.n33 in1.n31 54.7505
R720 in1.t3 in1.n5 1.69161
R721 in1.n35 in1.n31 47.4505
R722 in1.n11 in1.n8 47.2505
R723 in1.n23 in1.n20 47.2505
R724 in1.n17 in1.t7 40.1505
R725 in1.n32 in1.t6 28.6969
R726 in1.n19 in1.n17 28.0278
R727 in1.n13 in1.n10 23.1801
R728 in1.n17 in1.t8 19.2934
R729 in1.n4 in1.n26 5.12143
R730 in1.n12 in1.n3 16.9456
R731 in1.n26 in1.n24 15.5491
R732 in1.n16 in1.n15 11.2083
R733 in1.n24 in1.n22 11.0809
R734 in1.n16 in1.n6 10.702
R735 in1.n11 in1.n9 10.4505
R736 in1.n32 in1.n30 9.95505
R737 in1.n31 in1.n29 8.3955
R738 in1.n3 in1.n9 8.32713
R739 in1.n0 in1.n19 8.14204
R740 in1.n37 in1.n29 6.81383
R741 in1.n27 in1.t3 6.40912
R742 in1.n0 in1.n27 6.3005
R743 in1.n13 in1.n9 5.73172
R744 in1.n33 in1.n32 5.60586
R745 in1.n37 in1.n36 5.55593
R746 in1 in1.n16 5.3195
R747 in1.n19 in1.n18 5.2005
R748 in1.t6 in1.n28 4.56693
R749 in1.n36 in1.n30 4.41092
R750 in1.n29 in1.n28 3.91121
R751 in1.n12 in1.n1 5.38578
R752 in1.n34 in1.n30 3.6505
R753 in1.n36 in1.n35 3.6505
R754 in1.n14 in1.n13 3.1505
R755 in1.n14 in1.n8 3.1505
R756 in1.t5 in1.n11 3.1505
R757 in1.n22 in1.n21 3.1505
R758 in1.n20 in1.n5 87.9163
R759 in1.n15 in1.t5 2.93326
R760 in1.t3 in1.n4 0.161734
R761 in1 in1.n38 2.66717
R762 in1.n38 in1.n28 2.2635
R763 in1.t5 in1.n3 2.1221
R764 in1.n34 in1.n33 1.95586
R765 in1.n10 in1.n12 1.92498
R766 in1.n5 in1.n21 0.106663
R767 in1.n35 in1.n34 1.8255
R768 in1.n1 in1.n7 3.86742
R769 in1.n14 in1.n2 0.0332878
R770 in1.n7 in1.n2 48.9364
R771 in1.n23 in1.n21 1.7505
R772 in1.n15 in1.n7 1.62981
R773 in1.n27 in1.n20 1.62981
R774 in1.n4 in1.n20 3.93332
R775 in1 in1.n0 1.61473
R776 in1.n6 in1.t1 1.41684
R777 in1.n6 in1.t2 1.41684
R778 in1.n18 in1.t4 1.41684
R779 in1.n18 in1.t0 1.41684
R780 in1.n26 in1.n25 1.32827
R781 in1.n38 in1.n37 1.0225
R782 CLKb.n12 CLKb.t2 50.9005
R783 CLKb.n6 CLKb.t5 50.4632
R784 CLKb.n5 CLKb.t7 40.1505
R785 CLKb.n2 CLKb.n13 32.5888
R786 CLKb.n6 CLKb.t6 31.8076
R787 CLKb.n5 CLKb.t8 19.2934
R788 CLKb.n13 CLKb.n12 16.9387
R789 CLKb CLKb.n3 11.3091
R790 CLKb.n9 CLKb.n5 11.1192
R791 CLKb.n12 CLKb.n0 11.9058
R792 CLKb.n8 CLKb.t4 14.6423
R793 CLKb.n7 CLKb.n6 7.83926
R794 CLKb.n7 CLKb.t3 8.87861
R795 CLKb.n3 CLKb.n0 3.31861
R796 CLKb CLKb.n11 5.01887
R797 CLKb.n13 CLKb.n4 3.6505
R798 CLKb.n11 CLKb.n10 3.20364
R799 CLKb.n9 CLKb.n8 3.18376
R800 CLKb.n2 CLKb.n0 0.0474974
R801 CLKb.n1 CLKb.t2 0.459182
R802 CLKb.n1 CLKb.n4 0.825727
R803 CLKb.n10 CLKb.t0 1.41684
R804 CLKb.n10 CLKb.t1 1.41684
R805 CLKb.n11 CLKb.n9 1.06289
R806 CLKb.n8 CLKb.n7 1.01985
R807 CLKb.n3 CLKb.t2 5.88322
R808 CLKb.n3 CLKb.n4 1.7588
R809 CLKb.n2 CLKb.n1 1.57306
C0 out2 VDD 1.24664f
C1 CLK CLKN 0.48557f
C2 out1 a_2903_203r# 0.13364f
C3 VDD QN 0.82337f
C4 D CLKN 0.5238f
C5 VDD in2 0.50128f
C6 out1 VDD 1.00459f
C7 in1 CLKN 0.83329f
C8 in1 D 0.10806f
C9 CLKb CLKN 1.80641f
C10 Q QN 0.52563f
C11 CLKb D 0.40459f
C12 out2 CLKN 0.86265f
C13 CLKb in1 1.41885f
C14 out1 a_2135_203r# 0.36343f
C15 CLK VDD 0.58708f
C16 Q VDD 0.55791f
C17 in2 CLKN 0.91472f
C18 out1 CLKN 1.2713f
C19 out2 a_4107_203r# 0.39879f
C20 out2 QN 0.59218f
C21 CLKb in2 1.12429f
C22 out1 in1 1.49319f
C23 VDD CLKN 1.76986f
C24 D VDD 0.34242f
C25 CLKb out1 0.5922f
C26 D a_945_203r# 0.1386f
C27 out2 in2 1.5669f
C28 in1 VDD 0.50618f
C29 in1 a_945_203r# 0.1584f
C30 a_4107_203r# in2 0.15892f
C31 CLKb VDD 1.37955f
C32 Q VSS 0.88362f
C33 QN VSS 1.28371f
C34 D VSS 1.07848f
C35 CLK VSS 1.05119f
C36 VDD VSS 15.23846f
C37 a_4107_203r# VSS 0.35694f
C38 a_2903_203r# VSS 0.478f
C39 a_2135_203r# VSS 0.52599f
C40 a_945_203r# VSS 0.3821f
C41 out2 VSS 2.0152f
C42 in2 VSS 0.93368f
C43 out1 VSS 0.22994f
C44 in1 VSS 1.13772f
C45 CLKb VSS 1.60178f
C46 CLKb.n2 VSS 0.12882f
C47 CLKb.n5 VSS 0.17852f
C48 CLKb.n6 VSS 0.41884f
C49 CLKb.n7 VSS 1.08608f
C50 CLKb.n8 VSS 0.69613f
C51 CLKb.n9 VSS 0.62501f
C52 CLKb.t1 VSS 0.87979f
C53 CLKb.n10 VSS 0.16754f
C54 CLKb.n11 VSS 0.48441f
C55 CLKb.n12 VSS 0.1194f
C56 CLKb.n13 VSS 0.17528f
C57 in1.n0 VSS 0.57881f
C58 in1.t5 VSS 0.469f
C59 in1.t3 VSS 0.16679f
C60 in1.n6 VSS 0.18928f
C61 in1.n10 VSS 0.11596f
C62 in1.n16 VSS 0.6311f
C63 in1.n17 VSS 0.19049f
C64 in1.t0 VSS 0.16299f
C65 in1.t4 VSS 0.13519f
C66 in1.n18 VSS 0.12508f
C67 in1.n19 VSS 0.44692f
C68 in1.n28 VSS 0.13614f
C69 in1.n32 VSS 0.19674f
C70 in2.n0 VSS 0.88278f
C71 in2.t5 VSS 0.53224f
C72 in2.t1 VSS 0.17342f
C73 in2.t0 VSS 0.14846f
C74 in2.n4 VSS 0.22225f
C75 in2.n18 VSS 0.6447f
C76 in2.n19 VSS 0.21104f
C77 in2.t2 VSS 0.15455f
C78 in2.n20 VSS 0.1234f
C79 in2.n21 VSS 0.6121f
C80 out2.t1 VSS 0.54863f
C81 out2.n0 VSS 0.77234f
C82 out2.n1 VSS 0.24371f
C83 out2.n8 VSS 0.18877f
C84 out2.n9 VSS 0.27798f
C85 out2.n11 VSS 0.40337f
C86 out2.n12 VSS 0.20305f
C87 out2.t2 VSS 0.23198f
C88 out2.n13 VSS 0.17807f
C89 out2.t0 VSS 0.22974f
C90 a_828_987.t3 VSS 0.158f
C91 a_828_987.t2 VSS 0.36872f
C92 a_828_987.t0 VSS 0.33456f
C93 a_828_987.n0 VSS 0.76109f
C94 a_828_987.n1 VSS 0.1707f
C95 a_828_987.t1 VSS 0.15934f
C96 a_2044_987.t1 VSS 0.27264f
C97 a_2044_987.n0 VSS 0.17349f
C98 a_2044_987.n1 VSS 0.77352f
C99 a_2044_987.t2 VSS 0.27373f
C100 a_2812_987.t1 VSS 0.29978f
C101 a_2812_987.t0 VSS 0.17992f
C102 a_2812_987.t3 VSS 0.66313f
C103 a_2812_987.n0 VSS 0.17414f
C104 a_2812_987.n1 VSS 0.77641f
C105 a_2812_987.t2 VSS 0.27476f
C106 a_4028_987.t2 VSS 0.40048f
C107 a_4028_987.t1 VSS 0.17863f
C108 a_4028_987.t3 VSS 0.1709f
C109 a_4028_987.n0 VSS 0.18374f
C110 a_4028_987.n1 VSS 0.81924f
C111 a_4028_987.t0 VSS 0.34785f
C112 VSS.t23 VSS 0.19707f
C113 VSS.t17 VSS 0.14043f
C114 VSS.t7 VSS 0.26727f
C115 VSS.t5 VSS 0.18571f
C116 VSS.t13 VSS 0.30781f
C117 VSS.t3 VSS 0.24821f
C118 VDD.n0 VSS 0.60942f
C119 VDD.n1 VSS 0.35628f
C120 VDD.n2 VSS 0.23767f
C121 VDD.n3 VSS 0.21835f
C122 VDD.n36 VSS 0.13172f
C123 VDD.t47 VSS 0.11051f
C124 VDD.n49 VSS 0.16765f
C125 VDD.n52 VSS 0.16765f
C126 VDD.n55 VSS 0.11975f
C127 VDD.t39 VSS 0.58831f
C128 VDD.n58 VSS 0.11975f
C129 VDD.n64 VSS 0.11975f
C130 VDD.t29 VSS 0.12258f
C131 VDD.n66 VSS 0.11975f
C132 VDD.n69 VSS 0.11975f
C133 VDD.t16 VSS 0.84264f
C134 VDD.n72 VSS 0.11975f
C135 VDD.n75 VSS 0.11975f
C136 VDD.n76 VSS 0.11975f
C137 VDD.t6 VSS 0.16765f
C138 VDD.n79 VSS 0.11975f
C139 VDD.n81 VSS 0.16765f
C140 VDD.n84 VSS 0.11975f
C141 VDD.n86 VSS 0.10777f
C142 VDD.n89 VSS 0.10777f
C143 VDD.n90 VSS 0.16765f
C144 VDD.n91 VSS 0.10777f
C145 VDD.n94 VSS 0.10777f
C146 VDD.n95 VSS 0.16765f
C147 VDD.n96 VSS 0.10777f
C148 VDD.n99 VSS 0.10777f
C149 VDD.n101 VSS 0.11975f
C150 VDD.n104 VSS 0.16765f
C151 VDD.n106 VSS 0.11975f
C152 VDD.t21 VSS 0.16765f
C153 VDD.n109 VSS 0.11975f
C154 VDD.n110 VSS 0.13172f
C155 VDD.t8 VSS 0.16765f
C156 VDD.n113 VSS 0.11975f
C157 VDD.n114 VSS 0.13172f
C158 VDD.t0 VSS 0.16765f
C159 VDD.n117 VSS 0.11975f
C160 VDD.n118 VSS 0.11975f
C161 VDD.n121 VSS 0.10777f
C162 VDD.n122 VSS 0.1437f
C163 VDD.n123 VSS 0.15567f
C164 VDD.n126 VSS 0.10777f
C165 VDD.n127 VSS 0.11975f
C166 VDD.n128 VSS 0.10777f
C167 VDD.n131 VSS 0.15567f
C168 VDD.n132 VSS 0.26644f
C169 VDD.n134 VSS 0.23692f
C170 VDD.n135 VSS 0.23692f
C171 VDD.n140 VSS 0.21854f
C172 D.n0 VSS 0.33182f
C173 QN.t1 VSS 0.12242f
C174 QN.t2 VSS 0.11755f
C175 QN.n6 VSS 0.16159f
C176 QN.n8 VSS 0.10013f
C177 Q.t0 VSS 0.21535f
C178 Q.t1 VSS 0.1064f
C179 Q.t2 VSS 0.10426f
C180 Q.n5 VSS 0.10364f
C181 Q.n7 VSS 0.11986f
.ends
