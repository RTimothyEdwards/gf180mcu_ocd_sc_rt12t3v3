* NGSPICE file created from gf180mcu_ocd_sc_rt12t3v3__or2_1.ext - technology: gf180mcuD

.subckt gf180mcu_ocd_sc_rt12t3v3__or2_1 A B Y VDD VSS
X0 a_92_987.t1 B.t1 VDD.t3 VDD.t2 pfet_03v3 ad=0.3341p pd=1.805u as=0.3341p ps=1.805u w=1.285u l=0.28u
X1 a_193_203r# A.t0 VSS.t3 VSS.t2 nfet_03v3 ad=0.3087p pd=2.01u as=2.59775p ps=13.675u w=1.02u l=0.28u
X2 VDD.t9 a_193_203r# Y.t2 VDD.t8 pfet_03v3 ad=0.5654p pd=3.45u as=0.3341p ps=1.805u w=1.285u l=0.28u
X3 a_193_203r# A.t2 a_92_987.t2 VDD.t4 pfet_03v3 ad=0.3341p pd=1.805u as=0.3341p ps=1.805u w=1.285u l=0.28u
X4 VDD.t1 B.t2 a_92_987.t0 VDD.t0 pfet_03v3 ad=0.3341p pd=1.805u as=0.5654p ps=3.45u w=1.285u l=0.28u
X5 a_92_987.t3 A.t1 a_193_203r# VDD.t5 pfet_03v3 ad=0.5654p pd=3.45u as=0.3341p ps=1.805u w=1.285u l=0.28u
X6 Y.t0 a_193_203r# VDD.t7 VDD.t6 pfet_03v3 ad=0.3341p pd=1.805u as=0.5654p ps=3.45u w=1.285u l=0.28u
X7 Y.t1 a_193_203r# VSS.t5 VSS.t4 nfet_03v3 ad=0.3087p pd=2.01u as=2.59775p ps=13.675u w=1.02u l=0.28u
X8 a_193_203r# B.t0 VSS.t1 VSS.t0 nfet_03v3 ad=0.3087p pd=2.01u as=2.59775p ps=13.675u w=1.02u l=0.28u
R0 Y.n5 Y.t1 50.9005
R1 Y.n2 Y.n6 32.5888
R2 Y.n6 Y.n5 16.9387
R3 Y.n5 Y.n0 11.9058
R4 Y Y.n3 6.3455
R5 Y.n3 Y.n0 3.31861
R6 Y.n6 Y.n4 3.6505
R7 Y Y.n7 2.98717
R8 Y.n2 Y.n0 0.0474974
R9 Y.n1 Y.t1 0.459182
R10 Y.n1 Y.n4 0.825727
R11 Y.n7 Y.t0 1.41684
R12 Y.n7 Y.t2 1.41684
R13 Y.n3 Y.t1 5.88322
R14 Y.n3 Y.n4 1.7588
R15 Y.n2 Y.n1 1.57306
R16 A.n2 A.n0 2.51729
R17 A.t0 A.n1 105.85
R18 A.n8 A.t1 40.1505
R19 A.n6 A.n5 33.0983
R20 A.n8 A.t2 19.2934
R21 A.n5 A.n1 14.6005
R22 A A.n8 9.81947
R23 A.n5 A.n4 5.60586
R24 A A.n7 4.88485
R25 A.n7 A.n2 4.75155
R26 A.n3 A.n2 3.6505
R27 A.n4 A.n0 12.9345
R28 A.n3 A.t0 3.52014
R29 A.n6 A.n0 6.02145
R30 A.n2 A.n1 2.67746
R31 A.n4 A.n3 1.95586
R32 A.n7 A.n6 1.57039
R33 B.n0 B.t1 40.1505
R34 B B.n0 21.903
R35 B.n0 B.t2 19.2934
R36 B B.t0 9.09103
R37 VDD.n42 VDD.n41 186.852
R38 VDD.n40 VDD.n20 138.311
R39 VDD.n44 VDD.n43 137.088
R40 VDD.n29 VDD.n26 137.088
R41 VDD.n31 VDD.n25 137.088
R42 VDD.n36 VDD.n23 137.088
R43 VDD.n35 VDD.n34 135.863
R44 VDD.n44 VDD.t0 117.504
R45 VDD.n34 VDD.t5 117.504
R46 VDD.t8 VDD.n20 116.279
R47 VDD.t6 VDD.n35 99.1437
R48 VDD.n30 VDD.t2 97.9197
R49 VDD.t4 VDD.n30 97.9197
R50 VDD.t2 VDD.n29 39.1682
R51 VDD.n31 VDD.t4 39.1682
R52 VDD.n36 VDD.t6 37.9442
R53 VDD.n23 VDD.t8 20.8083
R54 VDD.n26 VDD.t0 19.5843
R55 VDD.n25 VDD.t5 19.5843
R56 VDD.n39 VDD.n38 9.888
R57 VDD.n46 VDD.n45 9.8005
R58 VDD.n45 VDD.n8 9.8005
R59 VDD.n9 VDD.n8 2.75725
R60 VDD.n28 VDD.n24 9.8005
R61 VDD.n32 VDD.n24 9.8005
R62 VDD.n6 VDD.n5 2.75725
R63 VDD.n33 VDD.n5 9.8005
R64 VDD.n10 VDD.n11 2.75725
R65 VDD.n37 VDD.n22 9.8005
R66 VDD.n7 VDD.n22 2.75725
R67 VDD.n17 VDD.n14 9.8005
R68 VDD.n16 VDD.n15 9.8005
R69 VDD.n33 VDD.n11 9.713
R70 VDD.n4 VDD.n21 4.93411
R71 VDD VDD.n46 6.3005
R72 VDD.n45 VDD.n44 6.3005
R73 VDD.n45 VDD 6.3005
R74 VDD.n26 VDD.n8 6.3005
R75 VDD VDD.n9 1.77287
R76 VDD.n29 VDD.n28 6.3005
R77 VDD.n28 VDD.n9 2.75725
R78 VDD.n30 VDD.n24 6.3005
R79 VDD.n24 VDD.n0 6.3005
R80 VDD.n32 VDD.n31 6.3005
R81 VDD.n6 VDD.n32 2.75725
R82 VDD.n25 VDD.n5 6.3005
R83 VDD.n0 VDD.n6 1.77287
R84 VDD.n34 VDD.n33 6.3005
R85 VDD.n33 VDD.n2 6.3005
R86 VDD.n35 VDD.n11 6.3005
R87 VDD.n2 VDD.n10 1.77287
R88 VDD.n37 VDD.n36 6.3005
R89 VDD.n10 VDD.n37 2.75725
R90 VDD.n23 VDD.n22 6.3005
R91 VDD.n2 VDD.n7 1.77287
R92 VDD.n38 VDD.n20 6.3005
R93 VDD.n38 VDD.n7 2.75725
R94 VDD.n40 VDD.n39 6.3005
R95 VDD.n39 VDD.n4 2.17736
R96 VDD.n41 VDD.n40 6.3005
R97 VDD.n2 VDD.n3 1.77287
R98 VDD.n4 VDD.n2 2.06282
R99 VDD.n15 VDD 6.3005
R100 VDD VDD.n16 6.3005
R101 VDD VDD.n17 6.3005
R102 VDD.n43 VDD.n14 6.3005
R103 VDD.n43 VDD.n42 6.3005
R104 VDD.n19 VDD.n1 5.4873
R105 VDD.n2 VDD.t7 4.32793
R106 VDD.n2 VDD.t9 4.32597
R107 VDD VDD.n27 2.89007
R108 VDD.n41 VDD.n1 2.82549
R109 VDD.n42 VDD.n18 2.82549
R110 VDD.n3 VDD.n19 5.514
R111 VDD.n3 VDD.n21 5.514
R112 VDD.n17 VDD.n13 2.75725
R113 VDD.n16 VDD.n13 2.75725
R114 VDD.n18 VDD.n14 2.73055
R115 VDD.n15 VDD.n12 2.17736
R116 VDD.n46 VDD.n12 2.17736
R117 VDD.n43 VDD.n12 2.06282
R118 VDD.n2 VDD.n1 2.03587
R119 VDD.n18 VDD 2.03587
R120 VDD.n40 VDD.n19 1.77287
R121 VDD.n40 VDD.n21 1.77287
R122 VDD.n43 VDD.n13 1.77287
R123 VDD.n27 VDD.t1 1.41684
R124 VDD.n27 VDD.t3 1.41684
R125 VDD.n2 VDD.n0 1.0445
R126 VDD VDD.n0 1.0445
R127 VSS.n36 VSS.n18 517.984
R128 VSS.n45 VSS.n44 513.399
R129 VSS.n27 VSS.n26 513.399
R130 VSS.n28 VSS.n27 513.399
R131 VSS.n28 VSS.n25 513.399
R132 VSS.n31 VSS.n30 513.399
R133 VSS.n35 VSS.n34 513.399
R134 VSS.n36 VSS.n35 513.399
R135 VSS.n31 VSS.n22 508.815
R136 VSS.n22 VSS.t4 348.378
R137 VSS.n30 VSS.t2 325.459
R138 VSS.n45 VSS.t0 316.291
R139 VSS.n42 VSS.n41 220.447
R140 VSS.n26 VSS.t0 197.109
R141 VSS.n25 VSS.t2 187.941
R142 VSS.n34 VSS.t4 165.022
R143 VSS.n37 VSS.n11 2.67226
R144 VSS.n46 VSS.n17 10.8894
R145 VSS.n29 VSS.n12 2.65609
R146 VSS.n32 VSS.n14 10.702
R147 VSS.n29 VSS.n24 10.4384
R148 VSS.n37 VSS.n15 10.3482
R149 VSS.n33 VSS.n13 2.53145
R150 VSS.n46 VSS.n5 9.76841
R151 VSS.n8 VSS.n16 9.44628
R152 VSS.n32 VSS.n8 9.27761
R153 VSS.n10 VSS.n17 7.38939
R154 VSS.n38 VSS.n19 7.38939
R155 VSS.n24 VSS.n7 2.35671
R156 VSS.n4 VSS.n15 2.24229
R157 VSS VSS.n42 5.41963
R158 VSS.n41 VSS 5.41963
R159 VSS.n46 VSS.n45 5.2005
R160 VSS VSS.n46 5.2005
R161 VSS.n44 VSS.n17 5.2005
R162 VSS.n17 VSS 5.2005
R163 VSS.n27 VSS.n24 5.2005
R164 VSS.n26 VSS.n5 5.2005
R165 VSS.n5 VSS 5.2005
R166 VSS.n25 VSS.n16 5.2005
R167 VSS.n12 VSS.n16 2.65609
R168 VSS.n29 VSS.n28 5.2005
R169 VSS VSS.n12 1.27346
R170 VSS.n30 VSS.n8 5.2005
R171 VSS.n8 VSS.n9 0.214594
R172 VSS.n22 VSS.n14 5.2005
R173 VSS.n13 VSS.n14 2.53145
R174 VSS.n32 VSS.n31 5.2005
R175 VSS VSS.n32 5.2005
R176 VSS.n35 VSS.n15 5.2005
R177 VSS VSS.n4 1.11716
R178 VSS.n34 VSS.n33 5.2005
R179 VSS.n13 VSS 1.33577
R180 VSS.n19 VSS.n18 5.2005
R181 VSS.n11 VSS.n19 2.67226
R182 VSS.n37 VSS.n36 5.2005
R183 VSS VSS.n11 1.26537
R184 VSS.n2 VSS 1.27115
R185 VSS.n39 VSS.n2 5.32092
R186 VSS.n38 VSS 5.2005
R187 VSS VSS.n10 5.2005
R188 VSS VSS.n1 1.27115
R189 VSS.n3 VSS.t5 4.4105
R190 VSS.n6 VSS.t1 4.4105
R191 VSS.n7 VSS.n6 1.42802
R192 VSS VSS.n9 1.8821
R193 VSS.n4 VSS.n3 1.3587
R194 VSS.n33 VSS.n3 3.12098
R195 VSS.n8 VSS.n21 2.7725
R196 VSS.n6 VSS.n23 2.7725
R197 VSS.n42 VSS.n0 2.66071
R198 VSS.n41 VSS.n40 2.66071
R199 VSS.n43 VSS.n10 2.66071
R200 VSS.n43 VSS.n1 5.32092
R201 VSS.n1 VSS.n0 5.32092
R202 VSS.n39 VSS.n38 2.66071
R203 VSS.n40 VSS.n2 5.32092
R204 VSS.n40 VSS.n18 1.27115
R205 VSS.n39 VSS.n18 1.27115
R206 VSS.n44 VSS.n43 1.27115
R207 VSS.n44 VSS.n0 1.27115
R208 VSS.t3 VSS.n9 4.54039
R209 VSS.n3 VSS.n20 2.9615
R210 VSS.n6 VSS.n5 2.71962
R211 VSS.n7 VSS 1.074
R212 a_92_987.n0 a_92_987.t0 4.97945
R213 a_92_987.n0 a_92_987.t3 4.89923
R214 a_92_987.n1 a_92_987.n0 2.6005
R215 a_92_987.n1 a_92_987.t2 1.41684
R216 a_92_987.t1 a_92_987.n1 1.41684
C0 VDD Y 0.5269f
C1 VDD a_193_203r# 0.47475f
C2 VDD A 0.34669f
C3 B A 0.14826f
C4 a_193_203r# Y 0.50387f
C5 VDD B 0.6279f
C6 a_193_203r# A 0.59808f
C7 Y VSS 1.04142f
C8 A VSS 0.73676f
C9 B VSS 1.03215f
C10 VDD VSS 4.40207f
C11 a_193_203r# VSS 0.17632f
C12 a_92_987.t2 VSS 0.11951f
C13 a_92_987.t3 VSS 0.30319f
C14 a_92_987.t0 VSS 0.29193f
C15 a_92_987.n0 VSS 0.75716f
C16 a_92_987.n1 VSS 0.15671f
C17 a_92_987.t1 VSS 0.12691f
C18 VSS.t1 VSS 0.17632f
C19 VDD.n2 VSS 0.22281f
C20 VDD.n20 VSS 0.14101f
C21 VDD.t9 VSS 0.39302f
C22 VDD.n30 VSS 0.10847f
C23 VDD.n34 VSS 0.14033f
C24 VDD.n35 VSS 0.13016f
C25 VDD.n40 VSS 0.24202f
C26 VDD.n43 VSS 0.24134f
C27 VDD.n44 VSS 0.14101f
C28 A.n5 VSS 0.15231f
C29 A.n6 VSS 0.22385f
C30 A.n8 VSS 0.1008f
C31 Y.n6 VSS 0.10904f
C32 Y.t2 VSS 0.40676f
.ends
