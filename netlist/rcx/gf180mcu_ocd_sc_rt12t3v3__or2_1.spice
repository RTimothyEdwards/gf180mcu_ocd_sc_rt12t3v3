* NGSPICE file created from gf180mcu_ocd_sc_rt12t3v3__or2_1.ext - technology: gf180mcuD

.subckt gf180mcu_ocd_sc_rt12t3v3__or2_1 A B Y VDD VSS
X0 a_92_987.t3 B.t1 VDD.t3 VDD.t2 pfet_03v3 ad=0.3341p pd=1.805u as=0.3341p ps=1.805u w=1.285u l=0.28u
X1 a_193_203r# A.t0 VSS.t1 VSS.t0 nfet_03v3 ad=0.3087p pd=2.01u as=2.59775p ps=13.675u w=1.02u l=0.28u
X2 VDD.t9 a_193_203r# Y.t0 VDD.t8 pfet_03v3 ad=0.5654p pd=3.45u as=0.3341p ps=1.805u w=1.285u l=0.28u
X3 a_193_203r# A.t2 a_92_987.t0 VDD.t0 pfet_03v3 ad=0.3341p pd=1.805u as=0.3341p ps=1.805u w=1.285u l=0.28u
X4 VDD.t5 B.t2 a_92_987.t2 VDD.t4 pfet_03v3 ad=0.3341p pd=1.805u as=0.5654p ps=3.45u w=1.285u l=0.28u
X5 a_92_987.t1 A.t1 a_193_203r# VDD.t1 pfet_03v3 ad=0.5654p pd=3.45u as=0.3341p ps=1.805u w=1.285u l=0.28u
X6 Y.t2 a_193_203r# VDD.t7 VDD.t6 pfet_03v3 ad=0.3341p pd=1.805u as=0.5654p ps=3.45u w=1.285u l=0.28u
X7 Y.t1 a_193_203r# VSS.t5 VSS.t4 nfet_03v3 ad=0.3087p pd=2.01u as=2.59775p ps=13.675u w=1.02u l=0.28u
X8 a_193_203r# B.t0 VSS.t3 VSS.t2 nfet_03v3 ad=0.3087p pd=2.01u as=2.59775p ps=13.675u w=1.02u l=0.28u
R0 Y.t1 Y.n0 3.32853
R1 Y Y.n1 2.98717
R2 Y.n1 Y.t2 1.41684
R3 Y.n1 Y.t0 1.41684
R4 Y Y.t1 7.04795
R5 A.n0 A.t1 40.1505
R6 A.n0 A.t2 19.2934
R7 A A.n0 9.81947
R8 A A.t0 16.4975
R9 B.n0 B.t1 40.1505
R10 B B.n0 21.903
R11 B.n0 B.t2 19.2934
R12 B B.t0 8.58764
R13 VDD.n42 VDD.n41 186.852
R14 VDD.n40 VDD.n20 138.311
R15 VDD.n44 VDD.n43 137.088
R16 VDD.n29 VDD.n26 137.088
R17 VDD.n31 VDD.n25 137.088
R18 VDD.n36 VDD.n23 137.088
R19 VDD.n35 VDD.n34 135.863
R20 VDD.n44 VDD.t4 117.504
R21 VDD.n34 VDD.t1 117.504
R22 VDD.t8 VDD.n20 116.279
R23 VDD.t6 VDD.n35 99.1437
R24 VDD.n30 VDD.t2 97.9197
R25 VDD.t0 VDD.n30 97.9197
R26 VDD.t2 VDD.n29 39.1682
R27 VDD.n31 VDD.t0 39.1682
R28 VDD.n36 VDD.t6 37.9442
R29 VDD.n23 VDD.t8 20.8083
R30 VDD.n26 VDD.t4 19.5843
R31 VDD.n25 VDD.t1 19.5843
R32 VDD.n39 VDD.n38 9.888
R33 VDD.n3 VDD.n19 5.514
R34 VDD.n46 VDD.n45 9.8005
R35 VDD.n45 VDD.n8 9.8005
R36 VDD.n9 VDD.n8 2.75725
R37 VDD.n28 VDD.n24 9.8005
R38 VDD.n32 VDD.n24 9.8005
R39 VDD.n6 VDD.n5 2.75725
R40 VDD.n33 VDD.n5 9.8005
R41 VDD.n10 VDD.n11 2.75725
R42 VDD.n37 VDD.n22 9.8005
R43 VDD.n7 VDD.n22 2.75725
R44 VDD.n17 VDD.n14 9.8005
R45 VDD.n16 VDD.n15 9.8005
R46 VDD.n33 VDD.n11 9.713
R47 VDD.n4 VDD.n21 4.93411
R48 VDD VDD.n46 6.3005
R49 VDD.n45 VDD.n44 6.3005
R50 VDD.n45 VDD 6.3005
R51 VDD.n26 VDD.n8 6.3005
R52 VDD VDD.n9 1.77287
R53 VDD.n29 VDD.n28 6.3005
R54 VDD.n28 VDD.n9 2.75725
R55 VDD.n30 VDD.n24 6.3005
R56 VDD.n24 VDD.n0 6.3005
R57 VDD.n32 VDD.n31 6.3005
R58 VDD.n6 VDD.n32 2.75725
R59 VDD.n25 VDD.n5 6.3005
R60 VDD.n0 VDD.n6 1.77287
R61 VDD.n34 VDD.n33 6.3005
R62 VDD.n33 VDD.n2 6.3005
R63 VDD.n35 VDD.n11 6.3005
R64 VDD.n2 VDD.n10 1.77287
R65 VDD.n37 VDD.n36 6.3005
R66 VDD.n10 VDD.n37 2.75725
R67 VDD.n23 VDD.n22 6.3005
R68 VDD.n2 VDD.n7 1.77287
R69 VDD.n38 VDD.n20 6.3005
R70 VDD.n38 VDD.n7 2.75725
R71 VDD.n40 VDD.n39 6.3005
R72 VDD.n39 VDD.n4 2.17736
R73 VDD.n41 VDD.n40 6.3005
R74 VDD.n3 VDD.n2 1.77287
R75 VDD.n4 VDD.n2 2.06282
R76 VDD.n15 VDD 6.3005
R77 VDD VDD.n16 6.3005
R78 VDD VDD.n17 6.3005
R79 VDD.n43 VDD.n14 6.3005
R80 VDD.n43 VDD.n42 6.3005
R81 VDD.n19 VDD.n1 5.4873
R82 VDD.n2 VDD.t7 4.32793
R83 VDD.n2 VDD.t9 4.32597
R84 VDD VDD.n27 2.89007
R85 VDD.n41 VDD.n1 2.82549
R86 VDD.n42 VDD.n18 2.82549
R87 VDD.n3 VDD.n21 5.514
R88 VDD.n17 VDD.n13 2.75725
R89 VDD.n16 VDD.n13 2.75725
R90 VDD.n18 VDD.n14 2.73055
R91 VDD.n15 VDD.n12 2.17736
R92 VDD.n46 VDD.n12 2.17736
R93 VDD.n43 VDD.n12 2.06282
R94 VDD.n2 VDD.n1 2.03587
R95 VDD.n18 VDD 2.03587
R96 VDD.n40 VDD.n19 1.77287
R97 VDD.n40 VDD.n21 1.77287
R98 VDD.n43 VDD.n13 1.77287
R99 VDD.n27 VDD.t5 1.41684
R100 VDD.n27 VDD.t3 1.41684
R101 VDD.n2 VDD.n0 1.0445
R102 VDD VDD.n0 1.0445
R103 VSS.n36 VSS.n18 517.984
R104 VSS.n45 VSS.n44 513.399
R105 VSS.n27 VSS.n26 513.399
R106 VSS.n28 VSS.n27 513.399
R107 VSS.n28 VSS.n25 513.399
R108 VSS.n31 VSS.n30 513.399
R109 VSS.n35 VSS.n34 513.399
R110 VSS.n36 VSS.n35 513.399
R111 VSS.n31 VSS.n22 508.815
R112 VSS.n22 VSS.t4 348.378
R113 VSS.n30 VSS.t0 325.459
R114 VSS.n45 VSS.t2 316.291
R115 VSS.n42 VSS.n41 220.447
R116 VSS.n26 VSS.t2 197.109
R117 VSS.n25 VSS.t0 187.941
R118 VSS.n34 VSS.t4 165.022
R119 VSS.n37 VSS.n11 2.67226
R120 VSS.n46 VSS.n17 10.8894
R121 VSS.n29 VSS.n12 2.65609
R122 VSS.n32 VSS.n14 10.702
R123 VSS.n29 VSS.n24 10.4384
R124 VSS.n37 VSS.n15 10.3482
R125 VSS.n33 VSS.n13 2.53145
R126 VSS.n46 VSS.n5 9.76841
R127 VSS.n8 VSS.n16 9.44628
R128 VSS.n32 VSS.n8 9.27761
R129 VSS.n10 VSS.n17 7.38939
R130 VSS.n38 VSS.n19 7.38939
R131 VSS.n24 VSS.n7 2.35671
R132 VSS.n4 VSS.n15 2.24229
R133 VSS VSS.n42 5.41963
R134 VSS.n41 VSS 5.41963
R135 VSS.n46 VSS.n45 5.2005
R136 VSS VSS.n46 5.2005
R137 VSS.n44 VSS.n17 5.2005
R138 VSS.n17 VSS 5.2005
R139 VSS.n27 VSS.n24 5.2005
R140 VSS.n26 VSS.n5 5.2005
R141 VSS.n5 VSS 5.2005
R142 VSS.n25 VSS.n16 5.2005
R143 VSS.n12 VSS.n16 2.65609
R144 VSS.n29 VSS.n28 5.2005
R145 VSS VSS.n12 1.27346
R146 VSS.n30 VSS.n8 5.2005
R147 VSS.n8 VSS.n9 0.214594
R148 VSS.n22 VSS.n14 5.2005
R149 VSS.n13 VSS.n14 2.53145
R150 VSS.n32 VSS.n31 5.2005
R151 VSS VSS.n32 5.2005
R152 VSS.n35 VSS.n15 5.2005
R153 VSS VSS.n4 1.11716
R154 VSS.n34 VSS.n33 5.2005
R155 VSS.n13 VSS 1.33577
R156 VSS.n19 VSS.n18 5.2005
R157 VSS.n11 VSS.n19 2.67226
R158 VSS.n37 VSS.n36 5.2005
R159 VSS VSS.n11 1.26537
R160 VSS.n2 VSS 1.27115
R161 VSS.n39 VSS.n2 5.32092
R162 VSS.n38 VSS 5.2005
R163 VSS VSS.n10 5.2005
R164 VSS VSS.n1 1.27115
R165 VSS.n3 VSS.n20 4.5995
R166 VSS.n8 VSS.n21 4.5995
R167 VSS.n6 VSS.n23 4.5995
R168 VSS.n3 VSS.t5 4.4105
R169 VSS.n6 VSS.t3 4.4105
R170 VSS.n7 VSS.n6 1.42802
R171 VSS VSS.n9 1.8821
R172 VSS.n4 VSS.n3 1.3587
R173 VSS.n42 VSS.n0 2.66071
R174 VSS.n41 VSS.n40 2.66071
R175 VSS.n43 VSS.n10 2.66071
R176 VSS.n43 VSS.n1 5.32092
R177 VSS.n1 VSS.n0 5.32092
R178 VSS.n39 VSS.n38 2.66071
R179 VSS.n40 VSS.n2 5.32092
R180 VSS.n40 VSS.n18 1.27115
R181 VSS.n39 VSS.n18 1.27115
R182 VSS.n44 VSS.n43 1.27115
R183 VSS.n44 VSS.n0 1.27115
R184 VSS.t1 VSS.n9 4.54039
R185 VSS.n33 VSS.n3 3.30998
R186 VSS.n6 VSS.n5 2.71962
R187 VSS.n7 VSS 1.074
R188 a_92_987.n0 a_92_987.t2 4.97945
R189 a_92_987.n0 a_92_987.t1 4.89923
R190 a_92_987.n1 a_92_987.n0 2.6005
R191 a_92_987.t0 a_92_987.n1 1.41684
R192 a_92_987.n1 a_92_987.t3 1.41684
C0 VDD A 0.34669f
C1 VDD a_193_203r# 0.47475f
C2 A a_193_203r# 0.59808f
C3 VDD Y 0.5269f
C4 VDD B 0.6279f
C5 B A 0.14826f
C6 a_193_203r# Y 0.50387f
C7 Y VSS 1.06158f
C8 A VSS 1.05488f
C9 B VSS 1.04026f
C10 VDD VSS 4.40207f
C11 a_193_203r# VSS 0.72603f
C12 a_92_987.t1 VSS 0.24629f
C13 a_92_987.t2 VSS 0.25682f
C14 a_92_987.n0 VSS 0.75716f
C15 a_92_987.n1 VSS 0.15671f
C16 VDD.n2 VSS 0.22281f
C17 VDD.n20 VSS 0.14101f
C18 VDD.n30 VSS 0.10847f
C19 VDD.n34 VSS 0.14033f
C20 VDD.n35 VSS 0.13016f
C21 VDD.n40 VSS 0.24202f
C22 VDD.n43 VSS 0.24134f
C23 VDD.n44 VSS 0.14101f
C24 B.t0 VSS 0.38345f
C25 B.n0 VSS 0.10238f
C26 A.t0 VSS 0.28354f
C27 Y.t1 VSS 0.15665f
C28 Y.n0 VSS 0.168f
.ends
