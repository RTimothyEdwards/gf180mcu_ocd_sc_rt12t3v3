* NGSPICE file created from gf180mcu_ocd_sc_rt12t3v3__nor2_1.ext - technology: gf180mcuD

.subckt gf180mcu_ocd_sc_rt12t3v3__nor2_1 A B Y VDD VSS
X0 a_92_987.t1 A.t1 VDD.t3 VDD.t2 pfet_03v3 ad=0.3341p pd=1.805u as=0.3341p ps=1.805u w=1.285u l=0.28u
X1 Y.t3 B.t0 VSS.t3 VSS.t2 nfet_03v3 ad=0.3087p pd=2.01u as=2.87915p ps=15.24u w=1.02u l=0.28u
X2 Y.t2 B.t2 a_92_987.t2 VDD.t4 pfet_03v3 ad=0.3341p pd=1.805u as=0.3341p ps=1.805u w=1.285u l=0.28u
X3 VDD.t1 A.t2 a_92_987.t0 VDD.t0 pfet_03v3 ad=0.3341p pd=1.805u as=0.5654p ps=3.45u w=1.285u l=0.28u
X4 a_92_987.t3 B.t1 Y.t0 VDD.t5 pfet_03v3 ad=0.5654p pd=3.45u as=0.3341p ps=1.805u w=1.285u l=0.28u
X5 Y.t1 A.t0 VSS.t1 VSS.t0 nfet_03v3 ad=0.3087p pd=2.01u as=2.87915p ps=15.24u w=1.02u l=0.28u
R0 Y.n10 Y.t1 50.9005
R1 Y.n12 Y.t3 50.9005
R2 Y.n5 Y.n11 32.5888
R3 Y.n2 Y.n13 32.5888
R4 Y.n13 Y.n12 19.8599
R5 Y.n11 Y.n10 16.9387
R6 Y.n10 Y.n3 11.9058
R7 Y.n12 Y.n0 11.9058
R8 Y Y.n14 6.85338
R9 Y Y.n7 6.6918
R10 Y Y.n6 6.6292
R11 Y.n6 Y.n3 3.31861
R12 Y.n7 Y.n0 3.31861
R13 Y.n11 Y.n8 3.6505
R14 Y.n13 Y.n9 3.6505
R15 Y.n5 Y.n3 0.0474974
R16 Y.n2 Y.n0 0.0474974
R17 Y.n4 Y.t1 0.459182
R18 Y.n1 Y.t3 0.459182
R19 Y.n4 Y.n8 0.825727
R20 Y.n1 Y.n9 0.825727
R21 Y.n14 Y.t2 1.41684
R22 Y.n14 Y.t0 1.41684
R23 Y.n6 Y.t1 5.88322
R24 Y.n7 Y.t3 5.88322
R25 Y.n7 Y.n9 1.7588
R26 Y.n6 Y.n8 1.7588
R27 Y.n5 Y.n4 1.57306
R28 Y.n2 Y.n1 1.57306
R29 B.n0 B.t2 40.1505
R30 B.n0 B.t1 19.2934
R31 B B.n0 15.0158
R32 B B.t0 9.19066
R33 A.n0 A.t1 40.1505
R34 A A.n0 21.903
R35 A.n0 A.t2 19.2934
R36 A A.t0 7.47829
R37 VDD.n34 VDD.n33 137.088
R38 VDD.n23 VDD.n20 137.088
R39 VDD.n25 VDD.n19 137.088
R40 VDD.n30 VDD.n16 137.088
R41 VDD.n32 VDD.n31 122.707
R42 VDD.n34 VDD.t0 117.504
R43 VDD.t5 VDD.n16 117.504
R44 VDD.n24 VDD.t2 97.9197
R45 VDD.t4 VDD.n24 97.9197
R46 VDD.t2 VDD.n23 39.1682
R47 VDD.n25 VDD.t4 39.1682
R48 VDD.n20 VDD.t0 19.5843
R49 VDD.n19 VDD.t5 19.5843
R50 VDD.n2 VDD.n15 5.514
R51 VDD.n36 VDD.n35 9.8005
R52 VDD.n35 VDD.n6 9.8005
R53 VDD.n7 VDD.n6 2.75725
R54 VDD.n22 VDD.n18 9.8005
R55 VDD.n26 VDD.n18 9.8005
R56 VDD.n4 VDD.n3 2.75725
R57 VDD.n27 VDD.n3 9.8005
R58 VDD.n29 VDD.n5 2.75725
R59 VDD.n13 VDD.n10 9.8005
R60 VDD.n12 VDD.n11 9.8005
R61 VDD.n29 VDD.n28 6.6505
R62 VDD VDD.n36 6.3005
R63 VDD.n35 VDD.n34 6.3005
R64 VDD.n35 VDD 6.3005
R65 VDD.n20 VDD.n6 6.3005
R66 VDD VDD.n7 1.77287
R67 VDD.n23 VDD.n22 6.3005
R68 VDD.n22 VDD.n7 2.75725
R69 VDD.n24 VDD.n18 6.3005
R70 VDD.n18 VDD.n0 6.3005
R71 VDD.n26 VDD.n25 6.3005
R72 VDD.n4 VDD.n26 2.75725
R73 VDD.n19 VDD.n3 6.3005
R74 VDD.n0 VDD.n4 1.77287
R75 VDD.n27 VDD.n16 6.3005
R76 VDD.n27 VDD.n5 2.75725
R77 VDD.n30 VDD.n29 6.3005
R78 VDD.n5 VDD.n0 1.77287
R79 VDD.n31 VDD.n30 6.3005
R80 VDD.n2 VDD.n0 1.77287
R81 VDD.n28 VDD.n0 6.3005
R82 VDD.n11 VDD 6.3005
R83 VDD VDD.n12 6.3005
R84 VDD VDD.n13 6.3005
R85 VDD.n33 VDD.n10 6.3005
R86 VDD.n33 VDD.n32 6.3005
R87 VDD.n15 VDD.n1 5.4873
R88 VDD VDD.n21 2.89007
R89 VDD.n31 VDD.n1 2.82549
R90 VDD.n32 VDD.n14 2.82549
R91 VDD.n28 VDD.n17 2.75725
R92 VDD.n2 VDD.n17 5.514
R93 VDD.n13 VDD.n9 2.75725
R94 VDD.n12 VDD.n9 2.75725
R95 VDD.n14 VDD.n10 2.73055
R96 VDD.n11 VDD.n8 2.17736
R97 VDD.n36 VDD.n8 2.17736
R98 VDD.n33 VDD.n8 2.06282
R99 VDD.n0 VDD.n1 2.03587
R100 VDD.n14 VDD 2.03587
R101 VDD.n30 VDD.n15 1.77287
R102 VDD.n30 VDD.n17 1.77287
R103 VDD.n33 VDD.n9 1.77287
R104 VDD VDD.n0 1.7525
R105 VDD.n21 VDD.t1 1.41684
R106 VDD.n21 VDD.t3 1.41684
R107 VSS.n34 VSS.n33 513.399
R108 VSS.n21 VSS.n20 513.399
R109 VSS.n22 VSS.n21 513.399
R110 VSS.n22 VSS.n19 513.399
R111 VSS.n25 VSS.n24 513.399
R112 VSS.n25 VSS.n14 513.399
R113 VSS.n24 VSS.t2 325.459
R114 VSS.n34 VSS.t0 316.291
R115 VSS.n20 VSS.t0 197.109
R116 VSS.n19 VSS.t2 187.941
R117 VSS.n31 VSS.n30 144.508
R118 VSS.n35 VSS.n13 10.8894
R119 VSS.n23 VSS.n10 2.65609
R120 VSS.n26 VSS.n11 2.6499
R121 VSS.n23 VSS.n18 10.4384
R122 VSS.n35 VSS.n4 9.76841
R123 VSS.n7 VSS.n12 9.44628
R124 VSS.n26 VSS.n7 9.27761
R125 VSS.n9 VSS.n13 7.38939
R126 VSS.n27 VSS.n15 7.38939
R127 VSS.n18 VSS.n6 2.35671
R128 VSS.n2 VSS.n31 5.41963
R129 VSS.n30 VSS 5.41963
R130 VSS.n35 VSS.n34 5.2005
R131 VSS VSS.n35 5.2005
R132 VSS.n33 VSS.n13 5.2005
R133 VSS.n13 VSS 5.2005
R134 VSS.n21 VSS.n18 5.2005
R135 VSS.n6 VSS 1.074
R136 VSS.n20 VSS.n4 5.2005
R137 VSS.n4 VSS 5.2005
R138 VSS.n19 VSS.n12 5.2005
R139 VSS.n10 VSS.n12 2.65609
R140 VSS.n23 VSS.n22 5.2005
R141 VSS VSS.n10 1.27346
R142 VSS.n24 VSS.n7 5.2005
R143 VSS.n7 VSS.n8 0.214594
R144 VSS.n15 VSS.n14 5.2005
R145 VSS.n11 VSS.n15 2.6499
R146 VSS.n26 VSS.n25 5.2005
R147 VSS VSS.n11 1.27655
R148 VSS.n3 VSS 1.27115
R149 VSS.n28 VSS.n3 5.32092
R150 VSS.n27 VSS 5.2005
R151 VSS VSS.n9 5.2005
R152 VSS.n2 VSS.n1 1.27115
R153 VSS.n5 VSS.t1 4.4105
R154 VSS.n6 VSS.n5 1.42802
R155 VSS VSS.n8 1.8821
R156 VSS.n7 VSS.n16 2.7725
R157 VSS.n5 VSS.n17 2.7725
R158 VSS.n31 VSS.n0 2.66071
R159 VSS.n30 VSS.n29 2.66071
R160 VSS.n32 VSS.n9 2.66071
R161 VSS.n32 VSS.n1 5.32092
R162 VSS.n1 VSS.n0 5.32092
R163 VSS.n28 VSS.n27 2.66071
R164 VSS.n29 VSS.n3 5.32092
R165 VSS.n29 VSS.n14 1.27115
R166 VSS.n28 VSS.n14 1.27115
R167 VSS.n33 VSS.n32 1.27115
R168 VSS.n33 VSS.n0 1.27115
R169 VSS.t3 VSS.n8 4.54039
R170 VSS.n5 VSS.n4 2.71962
R171 VSS.n2 VSS 1.38353
R172 a_92_987.n0 a_92_987.t0 4.97945
R173 a_92_987.n0 a_92_987.t3 4.89923
R174 a_92_987.n1 a_92_987.n0 2.6005
R175 a_92_987.n1 a_92_987.t2 1.41684
R176 a_92_987.t1 a_92_987.n1 1.41684
C0 VDD B 0.40559f
C1 A Y 0.19072f
C2 A VDD 0.51768f
C3 B Y 0.29584f
C4 Y VSS 0.47445f
C5 B VSS 0.84058f
C6 A VSS 0.92533f
C7 VDD VSS 3.23057f
C8 a_92_987.t3 VSS 0.17227f
C9 a_92_987.t0 VSS 0.17821f
C10 a_92_987.n0 VSS 0.44011f
C11 VSS.t1 VSS 0.13872f
C12 VSS.t3 VSS 0.14585f
C13 VDD.n0 VSS 0.10654f
C14 VDD.n16 VSS 0.10439f
C15 VDD.n30 VSS 0.17866f
C16 VDD.n33 VSS 0.17866f
C17 VDD.n34 VSS 0.10439f
C18 Y.t1 VSS 0.14703f
C19 Y.t3 VSS 0.15416f
.ends
