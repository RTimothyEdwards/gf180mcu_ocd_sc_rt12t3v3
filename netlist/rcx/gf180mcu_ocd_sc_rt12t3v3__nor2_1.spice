* NGSPICE file created from gf180mcu_ocd_sc_rt12t3v3__nor2_1.ext - technology: gf180mcuD

.subckt gf180mcu_ocd_sc_rt12t3v3__nor2_1 A B Y VDD VSS
X0 a_92_987.t3 A.t1 VDD.t5 VDD.t4 pfet_03v3 ad=0.3341p pd=1.805u as=0.3341p ps=1.805u w=1.285u l=0.28u
X1 Y.t2 B.t0 VSS.t1 VSS.t0 nfet_03v3 ad=0.3087p pd=2.01u as=2.87915p ps=15.24u w=1.02u l=0.28u
X2 Y.t3 B.t2 a_92_987.t0 VDD.t0 pfet_03v3 ad=0.3341p pd=1.805u as=0.3341p ps=1.805u w=1.285u l=0.28u
X3 VDD.t3 A.t2 a_92_987.t2 VDD.t2 pfet_03v3 ad=0.3341p pd=1.805u as=0.5654p ps=3.45u w=1.285u l=0.28u
X4 a_92_987.t1 B.t1 Y.t0 VDD.t1 pfet_03v3 ad=0.5654p pd=3.45u as=0.3341p ps=1.805u w=1.285u l=0.28u
X5 Y.t1 A.t0 VSS.t3 VSS.t2 nfet_03v3 ad=0.3087p pd=2.01u as=2.87915p ps=15.24u w=1.02u l=0.28u
R0 Y.n2 Y.n0 3.37947
R1 Y Y.n0 7.27136
R2 Y.t1 Y.n1 3.32853
R3 Y.t2 Y.n0 0.645433
R4 Y.n3 Y.t3 1.41684
R5 Y.n3 Y.t0 1.41684
R6 Y Y.t1 7.33165
R7 Y Y.n3 6.85338
R8 B.n0 B.t2 40.1505
R9 B.n0 B.t1 19.2934
R10 B B.n0 15.0158
R11 B B.t0 11.4916
R12 A.n0 A.t1 40.1505
R13 A A.n0 21.903
R14 A.n0 A.t2 19.2934
R15 A A.t0 7.05126
R16 VDD.n34 VDD.n33 137.088
R17 VDD.n23 VDD.n20 137.088
R18 VDD.n25 VDD.n19 137.088
R19 VDD.n30 VDD.n16 137.088
R20 VDD.n32 VDD.n31 122.707
R21 VDD.n34 VDD.t2 117.504
R22 VDD.t1 VDD.n16 117.504
R23 VDD.n24 VDD.t4 97.9197
R24 VDD.t0 VDD.n24 97.9197
R25 VDD.t4 VDD.n23 39.1682
R26 VDD.n25 VDD.t0 39.1682
R27 VDD.n20 VDD.t2 19.5843
R28 VDD.n19 VDD.t1 19.5843
R29 VDD.n2 VDD.n15 5.514
R30 VDD.n36 VDD.n35 9.8005
R31 VDD.n35 VDD.n6 9.8005
R32 VDD.n7 VDD.n6 2.75725
R33 VDD.n22 VDD.n18 9.8005
R34 VDD.n26 VDD.n18 9.8005
R35 VDD.n4 VDD.n3 2.75725
R36 VDD.n27 VDD.n3 9.8005
R37 VDD.n29 VDD.n5 2.75725
R38 VDD.n13 VDD.n10 9.8005
R39 VDD.n12 VDD.n11 9.8005
R40 VDD.n29 VDD.n28 6.6505
R41 VDD VDD.n36 6.3005
R42 VDD.n35 VDD.n34 6.3005
R43 VDD.n35 VDD 6.3005
R44 VDD.n20 VDD.n6 6.3005
R45 VDD VDD.n7 1.77287
R46 VDD.n23 VDD.n22 6.3005
R47 VDD.n22 VDD.n7 2.75725
R48 VDD.n24 VDD.n18 6.3005
R49 VDD.n18 VDD.n0 6.3005
R50 VDD.n26 VDD.n25 6.3005
R51 VDD.n4 VDD.n26 2.75725
R52 VDD.n19 VDD.n3 6.3005
R53 VDD.n0 VDD.n4 1.77287
R54 VDD.n27 VDD.n16 6.3005
R55 VDD.n27 VDD.n5 2.75725
R56 VDD.n30 VDD.n29 6.3005
R57 VDD.n5 VDD.n0 1.77287
R58 VDD.n31 VDD.n30 6.3005
R59 VDD.n2 VDD.n0 1.77287
R60 VDD.n28 VDD.n0 6.3005
R61 VDD.n11 VDD 6.3005
R62 VDD VDD.n12 6.3005
R63 VDD VDD.n13 6.3005
R64 VDD.n33 VDD.n10 6.3005
R65 VDD.n33 VDD.n32 6.3005
R66 VDD.n15 VDD.n1 5.4873
R67 VDD VDD.n21 2.89007
R68 VDD.n31 VDD.n1 2.82549
R69 VDD.n32 VDD.n14 2.82549
R70 VDD.n28 VDD.n17 2.75725
R71 VDD.n2 VDD.n17 5.514
R72 VDD.n13 VDD.n9 2.75725
R73 VDD.n12 VDD.n9 2.75725
R74 VDD.n14 VDD.n10 2.73055
R75 VDD.n11 VDD.n8 2.17736
R76 VDD.n36 VDD.n8 2.17736
R77 VDD.n33 VDD.n8 2.06282
R78 VDD.n0 VDD.n1 2.03587
R79 VDD.n14 VDD 2.03587
R80 VDD.n30 VDD.n15 1.77287
R81 VDD.n30 VDD.n17 1.77287
R82 VDD.n33 VDD.n9 1.77287
R83 VDD VDD.n0 1.7525
R84 VDD.n21 VDD.t3 1.41684
R85 VDD.n21 VDD.t5 1.41684
R86 VSS.n34 VSS.n33 513.399
R87 VSS.n21 VSS.n20 513.399
R88 VSS.n22 VSS.n21 513.399
R89 VSS.n22 VSS.n19 513.399
R90 VSS.n25 VSS.n24 513.399
R91 VSS.n25 VSS.n14 513.399
R92 VSS.n24 VSS.t0 325.459
R93 VSS.n34 VSS.t2 316.291
R94 VSS.n20 VSS.t2 197.109
R95 VSS.n19 VSS.t0 187.941
R96 VSS.n31 VSS.n30 144.508
R97 VSS.n35 VSS.n13 10.8894
R98 VSS.n23 VSS.n10 2.65609
R99 VSS.n26 VSS.n11 2.6499
R100 VSS.n23 VSS.n18 10.4384
R101 VSS.n35 VSS.n4 9.76841
R102 VSS.n7 VSS.n12 9.44628
R103 VSS.n26 VSS.n7 9.27761
R104 VSS.n9 VSS.n13 7.38939
R105 VSS.n27 VSS.n15 7.38939
R106 VSS.n18 VSS.n6 2.35671
R107 VSS.n2 VSS.n31 5.41963
R108 VSS.n30 VSS 5.41963
R109 VSS.n35 VSS.n34 5.2005
R110 VSS VSS.n35 5.2005
R111 VSS.n33 VSS.n13 5.2005
R112 VSS.n13 VSS 5.2005
R113 VSS.n21 VSS.n18 5.2005
R114 VSS.n6 VSS 1.074
R115 VSS.n20 VSS.n4 5.2005
R116 VSS.n4 VSS 5.2005
R117 VSS.n19 VSS.n12 5.2005
R118 VSS.n10 VSS.n12 2.65609
R119 VSS.n23 VSS.n22 5.2005
R120 VSS VSS.n10 1.27346
R121 VSS.n24 VSS.n7 5.2005
R122 VSS.n7 VSS.n8 0.214594
R123 VSS.n15 VSS.n14 5.2005
R124 VSS.n11 VSS.n15 2.6499
R125 VSS.n26 VSS.n25 5.2005
R126 VSS VSS.n11 1.27655
R127 VSS.n3 VSS 1.27115
R128 VSS.n28 VSS.n3 5.32092
R129 VSS.n27 VSS 5.2005
R130 VSS VSS.n9 5.2005
R131 VSS.n2 VSS.n1 1.27115
R132 VSS.n7 VSS.n16 4.5995
R133 VSS.n5 VSS.n17 4.5995
R134 VSS.n5 VSS.t3 4.4105
R135 VSS.n6 VSS.n5 1.42802
R136 VSS VSS.n8 1.8821
R137 VSS.n31 VSS.n0 2.66071
R138 VSS.n30 VSS.n29 2.66071
R139 VSS.n32 VSS.n9 2.66071
R140 VSS.n32 VSS.n1 5.32092
R141 VSS.n1 VSS.n0 5.32092
R142 VSS.n28 VSS.n27 2.66071
R143 VSS.n29 VSS.n3 5.32092
R144 VSS.n29 VSS.n14 1.27115
R145 VSS.n28 VSS.n14 1.27115
R146 VSS.n33 VSS.n32 1.27115
R147 VSS.n33 VSS.n0 1.27115
R148 VSS.t1 VSS.n8 4.54039
R149 VSS.n5 VSS.n4 2.71962
R150 VSS.n2 VSS 1.38353
R151 a_92_987.n0 a_92_987.t2 4.97945
R152 a_92_987.n0 a_92_987.t1 4.89923
R153 a_92_987.n1 a_92_987.n0 2.6005
R154 a_92_987.t0 a_92_987.n1 1.41684
R155 a_92_987.n1 a_92_987.t3 1.41684
C0 B Y 0.47626f
C1 A Y 0.29818f
C2 B VDD 0.46629f
C3 A VDD 0.62594f
C4 Y VSS 0.78131f
C5 B VSS 0.99769f
C6 A VSS 1.08866f
C7 VDD VSS 3.28216f
C8 a_92_987.t1 VSS 0.24688f
C9 a_92_987.t2 VSS 0.25744f
C10 a_92_987.n0 VSS 0.75897f
C11 a_92_987.n1 VSS 0.15709f
C12 VDD.n0 VSS 0.1507f
C13 VDD.n16 VSS 0.14766f
C14 VDD.n23 VSS 0.10223f
C15 VDD.n24 VSS 0.11359f
C16 VDD.n25 VSS 0.10223f
C17 VDD.n30 VSS 0.25273f
C18 VDD.n33 VSS 0.25273f
C19 VDD.n34 VSS 0.14766f
C20 A.t0 VSS 0.408f
C21 A.n0 VSS 0.11258f
C22 B.t0 VSS 0.41404f
C23 Y.t1 VSS 0.12613f
C24 Y.n1 VSS 0.13389f
C25 Y.n2 VSS 0.1436f
C26 Y.n3 VSS 0.107f
.ends
