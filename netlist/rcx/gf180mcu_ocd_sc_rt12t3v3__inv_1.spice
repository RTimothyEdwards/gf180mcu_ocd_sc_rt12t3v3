* NGSPICE file created from gf180mcu_ocd_sc_rt12t3v3__inv_1.ext - technology: gf180mcuD

.subckt gf180mcu_ocd_sc_rt12t3v3__inv_1 A Y VDD VSS
X0 VDD.t3 A.t1 Y.t0 VDD.t2 pfet_03v3 ad=2.7424p pd=12.83u as=0.3341p ps=1.805u w=1.285u l=0.28u
X1 Y.t2 A.t2 VDD.t1 VDD.t0 pfet_03v3 ad=0.3341p pd=1.805u as=2.7424p ps=12.83u w=1.285u l=0.28u
X2 Y.t1 A.t0 VSS.t1 VSS.t0 nfet_03v3 ad=0.3087p pd=2.01u as=4.22095p ps=23.13u w=1.02u l=0.28u
R0 Y.t1 Y.n1 3.32853
R1 Y Y.n0 2.98876
R2 Y.n0 Y.t2 1.41684
R3 Y.n0 Y.t0 1.41684
R4 Y Y.t1 7.27295
R5 A.n0 A.t1 40.1505
R6 A.n0 A.t2 19.2934
R7 A A.n0 10.0207
R8 A A.t0 6.63071
R9 VDD.n28 VDD.n14 137.088
R10 VDD.n24 VDD.n23 137.088
R11 VDD.n22 VDD.n0 137.088
R12 VDD.t0 VDD.n14 117.504
R13 VDD.t2 VDD.n22 97.9197
R14 VDD.n19 VDD.n15 74.5982
R15 VDD.n23 VDD.t2 39.1682
R16 VDD.n24 VDD.t0 19.5843
R17 VDD.n29 VDD.n13 9.8005
R18 VDD.n25 VDD.n11 2.75725
R19 VDD.n25 VDD.n17 9.8005
R20 VDD.n21 VDD.n17 9.8005
R21 VDD.n10 VDD.n20 4.85219
R22 VDD.n8 VDD.n18 5.40705
R23 VDD VDD.n19 6.51963
R24 VDD.n29 VDD.n28 6.3005
R25 VDD VDD.n29 6.3005
R26 VDD.n14 VDD.n13 6.3005
R27 VDD.n13 VDD.n11 2.75725
R28 VDD.n25 VDD.n24 6.3005
R29 VDD VDD.n11 1.77287
R30 VDD.n23 VDD.n17 6.3005
R31 VDD.n17 VDD 6.3005
R32 VDD.n22 VDD.n21 6.3005
R33 VDD.n21 VDD.n10 2.75725
R34 VDD VDD.n10 1.77287
R35 VDD.n12 VDD 6.3005
R36 VDD.n6 VDD.n7 1.85802
R37 VDD.n9 VDD.n7 2.22249
R38 VDD.n28 VDD.n15 6.3005
R39 VDD VDD.n8 1.82635
R40 VDD.n1 VDD.n0 2.13272
R41 VDD.n4 VDD.n1 2.03756
R42 VDD.n4 VDD.n2 2.101
R43 VDD VDD.n2 2.101
R44 VDD.n20 VDD.n2 4.19594
R45 VDD.n29 VDD.n12 6.19113
R46 VDD.n1 VDD.n8 4.68735
R47 VDD.n26 VDD.n16 5.35538
R48 VDD.n16 VDD.n7 4.48286
R49 VDD.n5 VDD 2.91159
R50 VDD VDD.n3 2.90963
R51 VDD.n26 VDD.n15 2.82549
R52 VDD.n19 VDD.n18 2.75725
R53 VDD.n28 VDD.n27 2.1923
R54 VDD.n20 VDD.n0 2.10378
R55 VDD.n9 VDD.n26 2.03587
R56 VDD.n27 VDD.n12 1.91839
R57 VDD.n27 VDD.n6 1.91839
R58 VDD.n28 VDD.n16 1.83883
R59 VDD.n18 VDD.n0 1.77287
R60 VDD.n9 VDD 1.71963
R61 VDD.n5 VDD.t1 1.41684
R62 VDD.n3 VDD.t3 1.41684
R63 VDD.n4 VDD.n3 1.26229
R64 VDD.n6 VDD.n5 1.22714
R65 VSS.n15 VSS.n12 452.993
R66 VSS.n23 VSS.n8 452.736
R67 VSS.n18 VSS.n12 452.736
R68 VSS.t0 VSS.n8 254.665
R69 VSS.n18 VSS.t0 198.072
R70 VSS.n17 VSS.n5 10.8894
R71 VSS.n17 VSS.n13 10.8894
R72 VSS.n1 VSS.n19 2.66071
R73 VSS.n19 VSS.n11 10.8894
R74 VSS.n22 VSS.n6 10.4384
R75 VSS.n25 VSS.n2 9.76841
R76 VSS.n16 VSS.n15 7.43544
R77 VSS.n15 VSS.n14 7.43544
R78 VSS.n5 VSS.n7 7.38939
R79 VSS.n21 VSS.n20 7.38939
R80 VSS.n22 VSS.n4 2.35671
R81 VSS VSS.n25 5.2005
R82 VSS.n7 VSS 5.2005
R83 VSS.n23 VSS.n22 5.2005
R84 VSS.n4 VSS 1.074
R85 VSS.n23 VSS.n2 5.2005
R86 VSS.n2 VSS 5.2005
R87 VSS VSS.n21 5.2005
R88 VSS VSS.n6 5.2005
R89 VSS.n12 VSS.n11 5.2005
R90 VSS.n19 VSS.n18 5.2005
R91 VSS.n1 VSS.n0 1.27115
R92 VSS.n20 VSS.n8 5.2005
R93 VSS.n20 VSS.n1 2.66071
R94 VSS.n5 VSS.n8 5.2005
R95 VSS VSS.n5 5.2005
R96 VSS.n18 VSS.n17 5.2005
R97 VSS.n17 VSS 5.2005
R98 VSS.n13 VSS.n12 5.2005
R99 VSS.n3 VSS.n10 4.5995
R100 VSS.n3 VSS.t1 4.4105
R101 VSS.n4 VSS.n3 1.42802
R102 VSS.n3 VSS.n2 2.71962
R103 VSS.n24 VSS.n7 2.66071
R104 VSS.n6 VSS.n9 2.66071
R105 VSS.n21 VSS.n9 2.66071
R106 VSS.n25 VSS.n24 2.66071
R107 VSS.n14 VSS.n11 2.63361
R108 VSS.n16 VSS.n13 2.63361
R109 VSS VSS.n16 1.53032
R110 VSS.n14 VSS.n0 1.53032
R111 VSS.n24 VSS.n23 1.27115
R112 VSS.n23 VSS.n9 1.27115
R113 VSS VSS.n0 1.00862
C0 VDD Y 0.52525f
C1 VDD A 0.45284f
C2 A Y 0.48911f
C3 Y VSS 0.89797f
C4 A VSS 1.02196f
C5 VDD VSS 2.3406f
C6 VDD.n0 VSS 0.13902f
C7 VDD.n28 VSS 0.13902f
C8 A.t0 VSS 0.35979f
C9 Y.t1 VSS 0.16232f
C10 Y.n0 VSS 0.10156f
C11 Y.n1 VSS 0.1719f
.ends
