* NGSPICE file created from gf180mcu_ocd_sc_rt12t3v3__dffsr_1.ext - technology: gf180mcuD

.subckt gf180mcu_ocd_sc_rt12t3v3__dffsr_1 D CLK SN RN Q QN VDD VSS
X0 R.t1 RN.t2 VDD VDD.t12 pfet_03v3 ad=0.3341p pd=1.805u as=0.3341p ps=1.805u w=1.285u l=0.28u
X1 in1.t0 CLKb a_4039_203r# VSS.t12 nfet_03v3 ad=0.3087p pd=2.01u as=0.52065p ps=3.23u w=1.02u l=0.28u
X2 in1.t3 CLKN a_2065_203r# VSS.t19 nfet_03v3 ad=0.3087p pd=2.01u as=0.52065p ps=3.23u w=1.02u l=0.28u
X3 a_4039_203r# out1 VSS.t4 VSS.t22 nfet_03v3 ad=0.3087p pd=2.01u as=2.74793p ps=14.86u w=1.02u l=0.28u
X4 QN out2 VSS.t2 VSS.t9 nfet_03v3 ad=0.3087p pd=2.01u as=2.74793p ps=14.86u w=1.02u l=0.28u
X5 VDD CLK.t0 CLKN VDD.t21 pfet_03v3 ad=0.3341p pd=1.805u as=0.3341p ps=1.805u w=1.285u l=0.28u
X6 a_3938_987.t0 out1 VDD.t41 VDD.t42 pfet_03v3 ad=0.3341p pd=1.805u as=0.3341p ps=1.805u w=1.285u l=0.28u
X7 a_5474_987.t0 R.t4 out2 VDD.t0 pfet_03v3 ad=0.5654p pd=3.45u as=0.3341p ps=1.805u w=1.285u l=0.28u
X8 VDD.t16 out2 a_6694_987.t0 VDD.t15 pfet_03v3 ad=0.3341p pd=1.805u as=0.5654p ps=3.45u w=1.285u l=0.28u
X9 a_4706_987.t0 out1 VDD VDD.t43 pfet_03v3 ad=0.3341p pd=1.805u as=0.3341p ps=1.805u w=1.285u l=0.28u
X10 a_2065_203r# D VSS VSS.t6 nfet_03v3 ad=0.3087p pd=2.01u as=2.9769p ps=16.1u w=1.02u l=0.28u
X11 out1 SNb a_2824_203r# VSS.t16 nfet_03v3 ad=0.3087p pd=2.01u as=0.52065p ps=3.23u w=1.02u l=0.28u
X12 VDD D.t1 a_1948_987.t0 VDD.t8 pfet_03v3 ad=0.3341p pd=1.805u as=0.5654p ps=3.45u w=1.285u l=0.28u
X13 VDD SNb a_2717_987.t0 VDD.t30 pfet_03v3 ad=0.3341p pd=1.805u as=0.5654p ps=3.45u w=1.285u l=0.28u
X14 a_1948_987.t1 CLKb in1.t1 VDD.t23 pfet_03v3 ad=0.5654p pd=3.45u as=0.3341p ps=1.805u w=1.285u l=0.28u
X15 a_2717_987.t2 R.t6 out1 VDD.t6 pfet_03v3 ad=0.5654p pd=3.45u as=0.3341p ps=1.805u w=1.285u l=0.28u
X16 VDD SN.t1 a_921_203r# VDD.t11 pfet_03v3 ad=0.3341p pd=1.805u as=0.3341p ps=1.805u w=1.285u l=0.28u
X17 in2.t3 CLKN a_4706_987.t0 VDD.t37 pfet_03v3 ad=0.3341p pd=1.805u as=0.3341p ps=1.805u w=1.285u l=0.28u
X18 VDD out2 QN VDD.t18 pfet_03v3 ad=0.3341p pd=1.805u as=0.3341p ps=1.805u w=1.285u l=0.28u
X19 a_6795_203r# out2 VSS.t4 VSS.t10 nfet_03v3 ad=0.3087p pd=2.01u as=2.74793p ps=14.86u w=1.02u l=0.28u
X20 a_1948_987.t1 D.t0 VDD VDD.t7 pfet_03v3 ad=0.3341p pd=1.805u as=0.3341p ps=1.805u w=1.285u l=0.28u
X21 SNb a_921_203r# VSS VSS.t14 nfet_03v3 ad=0.3087p pd=2.01u as=2.9769p ps=16.1u w=1.02u l=0.28u
X22 a_2824_203r# in1.t3 VSS VSS.t5 nfet_03v3 ad=0.3087p pd=2.015u as=2.9769p ps=16.1u w=1.02u l=0.28u
X23 VDD in1.t5 a_2717_987.t1 VDD.t19 pfet_03v3 ad=0.3341p pd=1.805u as=0.5654p ps=3.45u w=1.285u l=0.28u
X24 VDD SNb a_5474_987.t2 VDD.t29 pfet_03v3 ad=0.3341p pd=1.805u as=0.5654p ps=3.45u w=1.285u l=0.28u
X25 CLKN CLK VSS VSS.t11 nfet_03v3 ad=0.3087p pd=2.01u as=2.9769p ps=16.1u w=1.02u l=0.28u
X26 SNb a_921_203r# VDD VDD.t26 pfet_03v3 ad=0.3341p pd=1.805u as=0.3341p ps=1.805u w=1.285u l=0.28u
X27 VDD RN.t1 R.t1 VDD.t13 pfet_03v3 ad=0.5654p pd=3.45u as=0.3341p ps=1.805u w=1.285u l=0.28u
X28 a_4706_987.t1 CLKN in2.t3 VDD.t38 pfet_03v3 ad=0.5654p pd=3.45u as=0.3341p ps=1.805u w=1.285u l=0.28u
X29 VDD in2.t5 a_5474_987.t1 VDD.t9 pfet_03v3 ad=0.3341p pd=1.805u as=0.5654p ps=3.45u w=1.285u l=0.28u
X30 Q.t0 QN.t2 VDD VDD.t1 pfet_03v3 ad=0.3341p pd=1.805u as=0.3341p ps=1.805u w=1.285u l=0.28u
X31 a_5574_203r# in2 VSS.t4 VSS.t15 nfet_03v3 ad=0.3087p pd=2.015u as=2.9769p ps=16.1u w=1.02u l=0.28u
X32 CLKb CLKN VDD VDD.t33 pfet_03v3 ad=0.3341p pd=1.805u as=0.3341p ps=1.805u w=1.285u l=0.28u
X33 a_5474_987.t0 SNb VDD VDD.t32 pfet_03v3 ad=0.3341p pd=1.805u as=0.3341p ps=1.805u w=1.285u l=0.28u
X34 a_2717_987.t1 in1.t4 VDD VDD.t5 pfet_03v3 ad=0.5654p pd=3.45u as=0.3341p ps=1.805u w=1.285u l=0.28u
X35 in1.t2 CLKN a_3938_987.t0 VDD.t35 pfet_03v3 ad=0.3341p pd=1.805u as=0.3341p ps=1.805u w=1.285u l=0.28u
X36 a_6694_987.t1 out2 VDD.t16 VDD.t17 pfet_03v3 ad=0.3341p pd=1.805u as=0.3341p ps=1.805u w=1.285u l=0.28u
X37 out2 SNb a_5574_203r# VSS.t17 nfet_03v3 ad=0.3087p pd=2.01u as=0.52065p ps=3.23u w=1.02u l=0.28u
X38 a_2717_987.t0 SNb VDD VDD.t31 pfet_03v3 ad=0.3341p pd=1.805u as=0.3341p ps=1.805u w=1.285u l=0.28u
X39 VDD QN.t1 Q.t0 VDD.t2 pfet_03v3 ad=0.5654p pd=3.45u as=0.3341p ps=1.805u w=1.285u l=0.28u
X40 a_921_203r# SN.t0 VSS VSS.t7 nfet_03v3 ad=0.3087p pd=2.01u as=2.9769p ps=16.1u w=1.02u l=0.28u
X41 Q.t1 QN.t0 VSS.t2 VSS.t1 nfet_03v3 ad=0.3087p pd=2.01u as=2.9769p ps=16.1u w=1.02u l=0.28u
X42 CLKN CLK.t1 VDD VDD.t20 pfet_03v3 ad=0.3341p pd=1.805u as=0.5654p ps=3.45u w=1.285u l=0.28u
X43 VDD CLKN CLKb VDD.t34 pfet_03v3 ad=0.5654p pd=3.45u as=0.3341p ps=1.805u w=1.285u l=0.28u
X44 VDD out1 a_4706_987.t0 VDD.t39 pfet_03v3 ad=0.3341p pd=1.805u as=0.5654p ps=3.45u w=1.285u l=0.28u
X45 in2.t0 CLKb a_6694_987.t1 VDD.t24 pfet_03v3 ad=0.3341p pd=1.805u as=0.3341p ps=1.805u w=1.285u l=0.28u
X46 CLKb CLKN VSS VSS.t18 nfet_03v3 ad=0.3087p pd=2.01u as=2.9769p ps=16.1u w=1.02u l=0.28u
X47 out1 R.t3 VSS VSS.t0 nfet_03v3 ad=0.3087p pd=2.01u as=2.74793p ps=14.86u w=1.02u l=0.28u
X48 a_921_203r# SN.t2 VDD VDD.t10 pfet_03v3 ad=0.3341p pd=1.805u as=0.5654p ps=3.45u w=1.285u l=0.28u
X49 in1.t1 CLKb a_1948_987.t1 VDD.t22 pfet_03v3 ad=0.3341p pd=1.805u as=0.3341p ps=1.805u w=1.285u l=0.28u
X50 out1 R.t7 a_2717_987.t0 VDD.t3 pfet_03v3 ad=0.3341p pd=1.805u as=0.3341p ps=1.805u w=1.285u l=0.28u
X51 in2.t1 CLKb a_4807_203r# VSS.t13 nfet_03v3 ad=0.3087p pd=2.01u as=0.52065p ps=3.23u w=1.02u l=0.28u
X52 VDD a_921_203r# SNb VDD pfet_03v3 ad=0.3341p pd=1.805u as=0.3341p ps=1.805u w=1.285u l=0.28u
X53 a_4807_203r# out1 VSS.t4 VSS.t21 nfet_03v3 ad=0.3087p pd=2.01u as=2.74793p ps=14.86u w=1.02u l=0.28u
X54 a_5474_987.t1 in2.t4 VDD VDD.t44 pfet_03v3 ad=0.5654p pd=3.45u as=0.3341p ps=1.805u w=1.285u l=0.28u
X55 a_6694_987.t1 CLKb in2.t0 VDD.t25 pfet_03v3 ad=0.5654p pd=3.45u as=0.3341p ps=1.805u w=1.285u l=0.28u
X56 QN out2 VDD VDD.t14 pfet_03v3 ad=0.3341p pd=1.805u as=0.5654p ps=3.45u w=1.285u l=0.28u
X57 R.t0 RN.t0 VSS VSS.t8 nfet_03v3 ad=0.3087p pd=2.015u as=2.9769p ps=16.1u w=1.02u l=0.28u
X58 out2 R.t2 VSS.t4 VSS.t3 nfet_03v3 ad=0.3087p pd=2.01u as=2.74793p ps=14.86u w=1.02u l=0.28u
X59 in2.t2 CLKN a_6795_203r# VSS.t20 nfet_03v3 ad=0.3087p pd=2.01u as=0.53235p ps=3.25u w=1.02u l=0.28u
X60 VDD.t41 out1 a_3938_987.t0 VDD.t40 pfet_03v3 ad=0.3341p pd=1.805u as=0.5654p ps=3.45u w=1.285u l=0.28u
X61 a_3938_987.t1 CLKN in1.t2 VDD.t36 pfet_03v3 ad=0.5654p pd=3.45u as=0.3341p ps=1.805u w=1.285u l=0.28u
X62 out2 R.t5 a_5474_987.t0 VDD.t4 pfet_03v3 ad=0.3341p pd=1.805u as=0.3341p ps=1.805u w=1.285u l=0.28u
R0 Q.n0 Q.n2 0.494649
R1 Q.n0 Q.t1 0.105869
R2 Q.n1 Q.t0 0.478226
R3 Q.n1 Q 0.212192
R4 Q.n1 Q.n0 1.29677
R5 QN QN.t1 5.70487
R6 QN QN.t2 5.23264
R7 QN QN.t0 1.22658
R8 D D.t0 4.29613
R9 D D.t1 3.2128
R10 RN RN.t1 6.85764
R11 RN RN.t2 4.0005
R12 RN.t0 RN 1.92786
R13 SN SN.t1 6.76922
R14 SN SN.t2 3.99332
R15 SN SN.t0 2.32935
R16 CLK.n0 CLK.t0 5.5005
R17 CLK.n0 CLK.t1 2.64336
R18 CLK CLK.n0 1.96204
R19 VDD VDD.t36 27.3672
R20 VDD VDD.t43 27.3672
R21 VDD VDD.t1 27.3672
R22 VDD VDD.t26 26.843
R23 VDD VDD.t12 26.843
R24 VDD VDD.t8 26.843
R25 VDD VDD.t6 25.6897
R26 VDD VDD.t42 25.6897
R27 VDD VDD.t32 25.6897
R28 VDD VDD.t30 24.5713
R29 VDD VDD.t38 24.5713
R30 VDD VDD.t44 24.5713
R31 VDD VDD.t24 24.5713
R32 VDD VDD.t14 24.5713
R33 VDD VDD.t19 22.7801
R34 VDD VDD.t21 22.3695
R35 VDD VDD.t33 22.3695
R36 VDD VDD.t10 22.3695
R37 VDD VDD.t22 22.3695
R38 VDD VDD.t23 22.3695
R39 VDD VDD.t0 19.5386
R40 VDD VDD.t17 19.5386
R41 VDD VDD.t3 17.3019
R42 VDD VDD.t4 17.3019
R43 VDD VDD.t15 17.3019
R44 VDD VDD.t13 13.4225
R45 VDD VDD.t37 8.91403
R46 VDD VDD.t9 8.91403
R47 VDD VDD.t25 8.91403
R48 VDD VDD.t35 5.55891
R49 VDD VDD.t29 5.55891
R50 VDD VDD.t2 5.55891
R51 VDD VDD.t39 5.55968
R52 VDD VDD.t18 8.91508
R53 VDD VDD.t7 13.4236
R54 VDD VDD.t11 13.4236
R55 VDD VDD.t40 17.3028
R56 VDD VDD.t31 19.5392
R57 VDD VDD.t5 21.9415
R58 VDD VDD.t34 13.4225
R59 VDD VDD.t20 13.4225
R60 VDD VDD.t41 1.67893
R61 VDD VDD.t16 1.04342
R62 VSS VSS.t5 49.11
R63 VSS VSS.t7 453.808
R64 VSS VSS.t6 113.567
R65 VSS.t2 VSS.t9 113.567
R66 VSS VSS.t2 189.43
R67 VSS VSS.t14 127.642
R68 VSS.t4 VSS.t12 125.716
R69 VSS VSS.t16 120.314
R70 VSS.t4 VSS.t13 104.763
R71 VSS VSS.t18 98.2424
R72 VSS VSS.t19 81.0283
R73 VSS.t4 VSS.t17 75.2992
R74 VSS.t7 VSS 59.5915
R75 VSS VSS.t0 45.4677
R76 VSS.t4 VSS.t20 17.6804
R77 VSS.t2 VSS 5.12687
R78 VSS.t2 VSS 4.89172
R79 VSS.t4 VSS 4.41185
R80 VSS.t4 VSS 4.14162
R81 VSS.t4 VSS 3.63868
R82 VSS.t2 VSS 3.37971
R83 VSS.t2 VSS 3.22141
R84 VSS.t4 VSS 3.15302
R85 VSS.t4 VSS 2.89537
R86 VSS.t4 VSS 2.70988
R87 VSS.t4 VSS 2.66663
R88 VSS.t4 VSS 2.3711
R89 VSS.t4 VSS 2.04177
R90 VSS.t4 VSS 1.712
R91 VSS VSS.t22 21.8958
R92 VSS.t11 VSS 126.335
R93 VSS.t4 VSS.t10 126.334
R94 VSS.t2 VSS.t1 119.13
R95 VSS.t4 VSS.t15 115.079
R96 VSS.t4 VSS.t3 106.686
R97 VSS VSS.t8 88.9363
R98 VSS.t4 VSS.t21 78.2103
R99 VSS.t4 VSS 1.51805
R100 VSS.t2 VSS.t4 1.15323
R101 a_6694_987.t1 a_6694_987.t0 1.16186
R102 a_5474_987.t0 a_5474_987.t2 1.59397
R103 a_5474_987.t2 a_5474_987.t1 1.05866
R104 a_4706_987.t1 a_4706_987.t0 1.907
R105 a_3938_987.t1 a_3938_987.t0 1.907
R106 a_2717_987.t0 a_2717_987.t2 1.59397
R107 a_2717_987.t0 a_2717_987.t1 1.06031
R108 a_1948_987.t1 a_1948_987.t0 1.16186
R109 in2.n0 in2.t4 5.19098
R110 in2.n0 in2.t5 2.64336
R111 in2 in2.t2 2.32447
R112 in2.t1 in2.t3 1.11478
R113 in2 in2.t1 1.08655
R114 in2.t3 in2.n0 1.01355
R115 in2.t2 in2.t0 1.06704
R116 R.n0 R.t4 5.5005
R117 R.n1 R.t6 5.5005
R118 R.n1 R.n0 4.62312
R119 R.n2 R.n1 2.73964
R120 R.n0 R.t5 2.64336
R121 R.n1 R.t7 2.64336
R122 R.n0 R.t2 2.23861
R123 R.n1 R.t3 1.64959
R124 R.t0 R.n2 1.04047
R125 R.n2 R.t1 1.03494
R126 in1.t0 in1.n2 0.0251473
R127 in1.n6 in1.n0 13.5005
R128 in1.n5 in1.n6 7.5005
R129 in1.n10 in1.t4 5.5005
R130 in1.t1 in1.n10 3.18922
R131 in1.n8 in1.n3 3.17838
R132 in1.n10 in1.t5 2.64336
R133 in1 in1.n0 2.40287
R134 in1.n3 in1.n4 2.32058
R135 in1.n5 in1.n7 1.5005
R136 in1.t3 in1.t1 1.23091
R137 in1.n4 in1.n7 1.14324
R138 in1 in1.t3 1.1194
R139 in1.n0 in1.t2 1.04222
R140 in1.n8 in1.n7 0.785598
R141 in1.n9 in1.n8 0.5005
R142 in1.n9 in1.n6 0.5005
R143 in1.t0 in1.n5 0.5005
R144 in1.n1 in1.t0 0.0156763
R145 in1.t0 in1.n4 0.322839
R146 in1.n2 in1.n0 0.616409
R147 in1.n9 in1.n1 0.251526
R148 in1.n3 in1.n2 1.04106
R149 in1.n0 in1.n1 1.02936
C0 CLKN out1 0.46099f
C1 a_921_203r# SN 0.23645f
C2 a_921_203r# SNb 0.25007f
C3 VDD out1 0.56714f
C4 a_4039_203r# out1 0.18322f
C5 CLKN D 0.19791f
C6 out2 a_6795_203r# 0.19773f
C7 CLKN in2 0.46799f
C8 RN CLKN 0.16037f
C9 CLKb out1 0.31287f
C10 VDD D 0.2785f
C11 VDD in2 0.39916f
C12 CLK CLKN 0.26296f
C13 VDD RN 0.35656f
C14 out1 in1 0.85605f
C15 VDD CLKN 1.41415f
C16 out2 in2 0.83009f
C17 VDD QN 0.60657f
C18 out2 CLKN 0.45247f
C19 out2 QN 0.31769f
C20 CLK VDD 0.45767f
C21 CLKN SN 0.21509f
C22 in2 SNb 0.21646f
C23 VDD out2 0.76581f
C24 CLKb D 0.15539f
C25 RN SNb 0.13204f
C26 CLKN SNb 0.93666f
C27 CLKb in2 0.65294f
C28 CLKb CLKN 1.00346f
C29 VDD SN 0.48344f
C30 VDD SNb 0.81273f
C31 a_2824_203r# in1 0.14957f
C32 CLKN in1 0.46051f
C33 VDD CLKb 1.06299f
C34 a_5574_203r# in2 0.14584f
C35 Q QN 0.27525f
C36 VDD in1 0.39194f
C37 VDD Q 0.29533f
C38 CLKb SN 0.23576f
C39 CLKN a_921_203r# 0.12936f
C40 CLKb SNb 2.00705f
C41 in1 SNb 0.22847f
C42 VDD a_921_203r# 0.46003f
C43 CLKb in1 0.72563f
C44 Q VSS -0.10926f
C45 QN VSS 1.81675f
C46 RN VSS 0.94906f
C47 SN VSS 0.93045f
C48 VDD VSS 32.86588f
C49 a_5574_203r# VSS 0.72742f
C50 a_4807_203r# VSS 0.28975f
C51 a_4039_203r# VSS 1.13586f
C52 a_2824_203r# VSS 1.57312f
C53 a_2065_203r# VSS 1.42734f
C54 out2 VSS 0.39742f
C55 SNb VSS 0.13132f
C56 in1 VSS 0.8636f
C57 in1.t2 VSS 0.29379f
C58 in1.n0 VSS 0.59049f
C59 in1.n3 VSS 0.11324f
C60 in1.t1 VSS 0.50634f
C61 in1.t0 VSS 0.64413f
C62 in1.n10 VSS 0.12374f
C63 R.n0 VSS 1.58387f
C64 R.n1 VSS 1.72537f
C65 R.t0 VSS 0.81463f
C66 R.t1 VSS 0.47711f
C67 R.n2 VSS 0.8795f
C68 in2.t1 VSS 0.82509f
C69 in2.t0 VSS 0.30909f
C70 in2.t2 VSS 0.87061f
C71 in2.t3 VSS 0.81049f
C72 in2.n0 VSS 0.17145f
C73 a_1948_987.t0 VSS 0.34475f
C74 a_1948_987.t1 VSS 0.55463f
C75 a_2717_987.t2 VSS 0.41982f
C76 a_2717_987.t0 VSS 0.76036f
C77 a_2717_987.t1 VSS 0.34199f
C78 a_3938_987.t0 VSS 0.41599f
C79 a_3938_987.t1 VSS 0.41702f
C80 a_4706_987.t0 VSS 0.74284f
C81 a_4706_987.t1 VSS 0.68646f
C82 a_5474_987.t2 VSS 0.79784f
C83 a_5474_987.t0 VSS 0.48199f
C84 a_5474_987.t1 VSS 0.33504f
C85 a_6694_987.t0 VSS 0.36083f
C86 a_6694_987.t1 VSS 0.5319f
C87 VSS.t4 VSS 1.70941f
C88 VSS.t2 VSS 0.56722f
C89 Q.t1 VSS 0.14388f
C90 Q.n0 VSS 0.15792f
C91 Q.t0 VSS 0.16059f
C92 Q.n1 VSS 0.51768f
.ends
