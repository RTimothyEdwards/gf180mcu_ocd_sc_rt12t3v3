* NGSPICE file created from gf180mcu_ocd_sc_rt12t3v3__tiel.ext - technology: gf180mcuD

.subckt gf180mcu_ocd_sc_rt12t3v3__tiel Y VDD VSS
X0 VDD a_93_147.t2 a_93_147.t1 VDD.t1 pfet_03v3 ad=2.7424p pd=12.83u as=0.3341p ps=1.805u w=1.285u l=0.28u
X1 a_93_147.t1 a_93_147.t0 VDD VDD.t0 pfet_03v3 ad=0.3341p pd=1.805u as=2.7424p ps=12.83u w=1.285u l=0.28u
X2 Y.t0 a_93_147.t3 VSS VSS.t0 nfet_03v3 ad=0.3087p pd=2.01u as=4.22095p ps=23.13u w=1.02u l=0.28u
R0 Y.t0 Y.n0 0.600552
R1 Y Y.n0 0.0005
R2 VDD VDD.t1 22.3695
R3 VDD VDD.t0 13.4225
R4 VSS VSS.t0 111.486
R5 a_93_147.t1 a_93_147.t2 4.03225
R6 a_93_147.t1 a_93_147.t0 3.47669
R7 a_93_147.t3 a_93_147.t1 1.47871
C0 VDD Y 0.1136f
C1 Y VSS 0.22456f
C2 VDD VSS 2.8701f
C3 a_93_147.t1 VSS 0.37955f
C4 Y.t0 VSS 0.3168f
.ends
