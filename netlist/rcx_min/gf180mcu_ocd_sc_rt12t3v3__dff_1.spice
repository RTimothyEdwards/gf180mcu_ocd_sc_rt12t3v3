* NGSPICE file created from gf180mcu_ocd_sc_rt12t3v3__dff_1.ext - technology: gf180mcuD

.subckt gf180mcu_ocd_sc_rt12t3v3__dff_1 D CLK Q QN VDD VSS
X0 a_828_987.t1 CLKb.t6 in1.t0 VDD.t11 pfet_03v3 ad=0.5654p pd=3.45u as=0.3341p ps=1.805u w=1.285u l=0.28u
X1 out1 in1.t6 VDD.t13 VDD.t12 pfet_03v3 ad=0.3341p pd=1.805u as=0.5654p ps=3.45u w=1.285u l=0.28u
X2 a_2812_987.t0 out1 VDD.t1 VDD.t27 pfet_03v3 ad=0.3341p pd=1.805u as=0.3341p ps=1.805u w=1.285u l=0.28u
X3 a_4028_987.t1 out2.t6 VDD.t1 VDD.t9 pfet_03v3 ad=0.3341p pd=1.805u as=0.3341p ps=1.805u w=1.285u l=0.28u
X4 CLKN CLK.t1 VDD VDD.t14 pfet_03v3 ad=0.3341p pd=1.805u as=19.0728p ps=0.12486m w=1.285u l=0.28u
X5 VDD.t1 CLKN CLKb.t0 VDD.t20 pfet_03v3 ad=0.5654p pd=3.45u as=0.3341p ps=1.805u w=1.285u l=0.28u
X6 VDD.t1 D.t1 a_828_987.t0 VDD.t0 pfet_03v3 ad=0.3341p pd=1.805u as=0.5654p ps=3.45u w=1.285u l=0.28u
X7 out2.t0 in2.t4 VDD.t1 VDD.t10 pfet_03v3 ad=0.5654p pd=3.45u as=0.3341p ps=1.805u w=1.285u l=0.28u
X8 in1.t3 CLKN a_945_203r# VSS.t11 nfet_03v3 ad=0.3087p pd=2.01u as=0.52065p ps=3.23u w=1.02u l=0.28u
X9 VDD.t1 out1 a_2044_987.t0 VDD.t24 pfet_03v3 ad=0.3341p pd=1.805u as=0.5654p ps=3.45u w=1.285u l=0.28u
X10 a_2044_987.t1 CLKN in1.t2 VDD.t22 pfet_03v3 ad=0.5654p pd=3.45u as=0.3341p ps=1.805u w=1.285u l=0.28u
X11 VDD.t1 out1 a_2812_987.t0 VDD.t26 pfet_03v3 ad=0.3341p pd=1.805u as=0.5654p ps=3.45u w=1.285u l=0.28u
X12 Q.t0 QN.t2 VDD.t1 VDD.t17 pfet_03v3 ad=0.3341p pd=1.805u as=0.3341p ps=1.805u w=1.285u l=0.28u
X13 QN out2.t2 VSS.t4 VSS.t3 nfet_03v3 ad=0.3087p pd=2.01u as=2.74232p ps=14.88u w=1.02u l=0.28u
X14 a_2044_987.t0 out1 VDD.t1 VDD.t25 pfet_03v3 ad=0.3341p pd=1.805u as=0.3341p ps=1.805u w=1.285u l=0.28u
X15 in2.t1 CLKb.t2 a_2903_203r# VSS.t7 nfet_03v3 ad=0.3087p pd=2.01u as=0.52065p ps=3.23u w=1.02u l=0.28u
X16 Q.t1 QN.t0 VSS.t4 VSS.t9 nfet_03v3 ad=0.3087p pd=2.01u as=3.08512p ps=16.74u w=1.02u l=0.28u
X17 a_2135_203r# out1 VSS VSS.t14 nfet_03v3 ad=0.3087p pd=2.01u as=2.74232p ps=14.88u w=1.02u l=0.28u
X18 a_2903_203r# out1 VSS VSS.t13 nfet_03v3 ad=0.3087p pd=2.01u as=2.74232p ps=14.88u w=1.02u l=0.28u
X19 a_828_987.t1 D.t0 VDD.t1 VDD.t2 pfet_03v3 ad=0.3341p pd=1.805u as=0.3341p ps=1.805u w=1.285u l=0.28u
X20 CLKN CLK VSS VSS.t6 nfet_03v3 ad=0.3087p pd=2.01u as=3.08512p ps=16.74u w=1.02u l=0.28u
X21 out1 in1.t4 VSS VSS.t5 nfet_03v3 ad=0.3087p pd=2.015u as=3.08512p ps=16.74u w=1.02u l=0.28u
X22 VDD.t1 in1.t5 out1 VDD.t7 pfet_03v3 ad=0.5654p pd=3.45u as=0.3341p ps=1.805u w=1.285u l=0.28u
X23 VDD.t1 QN.t1 Q.t0 VDD.t18 pfet_03v3 ad=0.5654p pd=3.45u as=0.3341p ps=1.805u w=1.285u l=0.28u
X24 in2.t0 CLKb.t5 a_4028_987.t1 VDD.t16 pfet_03v3 ad=0.3341p pd=1.805u as=0.3341p ps=1.805u w=1.285u l=0.28u
X25 in2.t2 CLKN a_2812_987.t0 VDD.t1 pfet_03v3 ad=0.3341p pd=1.805u as=0.3341p ps=1.805u w=1.285u l=0.28u
X26 VDD.t15 CLK.t0 CLKN VDD pfet_03v3 ad=0.3341p pd=1.805u as=0.3341p ps=1.805u w=1.285u l=0.28u
X27 in1.t1 CLKb.t3 a_2135_203r# VSS.t8 nfet_03v3 ad=0.3087p pd=2.01u as=0.52065p ps=3.23u w=1.02u l=0.28u
X28 a_4028_987.t1 CLKb.t4 in2.t0 VDD.t28 pfet_03v3 ad=0.5654p pd=3.45u as=0.3341p ps=1.805u w=1.285u l=0.28u
X29 a_2812_987.t1 CLKN in2.t2 VDD.t23 pfet_03v3 ad=0.5654p pd=3.45u as=0.3341p ps=1.805u w=1.285u l=0.28u
X30 QN out2.t5 VDD.t1 VDD.t8 pfet_03v3 ad=0.3341p pd=1.805u as=0.5654p ps=3.45u w=1.285u l=0.28u
X31 CLKb.t0 CLKN VDD.t15 VDD.t19 pfet_03v3 ad=0.3341p pd=1.805u as=0.3341p ps=1.805u w=1.285u l=0.28u
X32 CLKb.t1 CLKN VSS VSS.t10 nfet_03v3 ad=0.3087p pd=2.01u as=3.08512p ps=16.74u w=1.02u l=0.28u
X33 VDD.t1 in2.t5 out2.t0 VDD.t1 pfet_03v3 ad=0.3341p pd=1.805u as=0.5654p ps=3.45u w=1.285u l=0.28u
X34 in1.t2 CLKN a_2044_987.t0 VDD.t21 pfet_03v3 ad=0.3341p pd=1.805u as=0.3341p ps=1.805u w=1.285u l=0.28u
X35 in1.t0 CLKb.t7 a_828_987.t1 VDD.t6 pfet_03v3 ad=0.3341p pd=1.805u as=0.3341p ps=1.805u w=1.285u l=0.28u
X36 VDD.t1 out2.t4 QN VDD.t4 pfet_03v3 ad=0.3341p pd=1.805u as=0.3341p ps=1.805u w=1.285u l=0.28u
X37 in2.t3 CLKN a_4107_203r# VSS.t12 nfet_03v3 ad=0.3087p pd=2.01u as=0.53235p ps=3.25u w=1.02u l=0.28u
X38 a_945_203r# D VSS VSS.t0 nfet_03v3 ad=0.3087p pd=2.01u as=3.08512p ps=16.74u w=1.02u l=0.28u
X39 VDD.t1 out2.t7 a_4028_987.t0 VDD.t1 pfet_03v3 ad=0.3341p pd=1.805u as=0.5654p ps=3.45u w=1.285u l=0.28u
X40 out2.t1 in2.t1 VSS VSS.t2 nfet_03v3 ad=0.3087p pd=2.015u as=3.08512p ps=16.74u w=1.02u l=0.28u
X41 a_4107_203r# out2.t3 VSS VSS.t1 nfet_03v3 ad=0.3087p pd=2.01u as=2.74232p ps=14.88u w=1.02u l=0.28u
R0 Q.n0 Q.n2 0.494649
R1 Q.n0 Q.t1 0.105869
R2 Q.n1 Q.t0 0.47979
R3 Q.n1 Q 0.232891
R4 Q.n1 Q.n0 1.29677
R5 QN QN.t1 5.71875
R6 QN QN.t2 5.21875
R7 QN QN.t0 1.22658
R8 D D.t0 4.29613
R9 D D.t1 3.2128
R10 CLK.n0 CLK.t0 5.5005
R11 CLK.n0 CLK.t1 2.64336
R12 CLK CLK.n0 1.39061
R13 VDD VDD.t1 0.703719
R14 VDD VDD.t14 26.843
R15 VDD VDD.t19 26.843
R16 VDD.t1 VDD.t0 26.843
R17 VDD.t1 VDD.t22 26.843
R18 VDD.t1 VDD.t27 26.843
R19 VDD.t1 VDD.t23 26.843
R20 VDD.t1 VDD.t10 26.843
R21 VDD.t1 VDD.t9 26.843
R22 VDD.t1 VDD.t6 22.3695
R23 VDD.t1 VDD.t11 22.3695
R24 VDD.t1 VDD.t12 22.3695
R25 VDD.t1 VDD.t7 22.3695
R26 VDD.t1 VDD.t24 22.3695
R27 VDD.t1 VDD.t25 22.3695
R28 VDD.t1 VDD.t28 22.3695
R29 VDD.t1 VDD.t4 22.3695
R30 VDD.t1 VDD.t17 22.3695
R31 VDD.t1 VDD.t20 13.4225
R32 VDD.t1 VDD.t21 13.4225
R33 VDD.t1 VDD.t16 13.4225
R34 VDD.t1 VDD.t26 13.4236
R35 VDD.t1 VDD.t2 13.4236
R36 VDD VDD.t15 0.46667
R37 VDD.t1 VDD.t8 13.4225
R38 VDD.t1 VDD.t18 13.4225
R39 VDD.t1 VDD.t13 1.11113
R40 VSS VSS.t5 49.11
R41 VSS VSS.t0 113.566
R42 VSS.t4 VSS.t3 113.567
R43 VSS VSS.t4 128.339
R44 VSS VSS.t8 125.716
R45 VSS VSS.t7 104.763
R46 VSS VSS.t10 98.2424
R47 VSS VSS.t11 81.0283
R48 VSS VSS.t12 17.6804
R49 VSS.t4 VSS 3.42447
R50 VSS.t4 VSS 3.18932
R51 VSS.t4 VSS 2.22554
R52 VSS.t4 VSS 2.06724
R53 VSS VSS.t14 21.8958
R54 VSS.t6 VSS 126.335
R55 VSS VSS.t1 126.334
R56 VSS.t4 VSS.t9 119.13
R57 VSS VSS.t2 115.079
R58 VSS VSS.t13 78.2103
R59 VSS.t4 VSS 1.15032
R60 a_4028_987.t0 a_4028_987.t1 1.907
R61 a_2812_987.t1 a_2812_987.t0 1.907
R62 a_2044_987.t1 a_2044_987.t0 1.907
R63 a_828_987.t1 a_828_987.t0 1.16186
R64 out2.n0 out2.t4 5.80209
R65 out2.n1 out2.t6 5.28225
R66 out2.n0 out2.t5 5.13542
R67 out2.n1 out2.t7 2.64336
R68 out2.n0 out2.t2 1.74074
R69 out2.t1 out2.n0 1.59465
R70 out2.t1 out2.t3 1.37914
R71 out2.t1 out2.t0 1.13779
R72 out2.t0 out2.n1 1.04252
R73 in2.n1 in2.t4 5.19098
R74 in2.n1 in2.t5 2.64336
R75 in2.t1 in2.t2 1.81464
R76 in2.t1 in2.t3 1.25908
R77 in2.t3 in2.n0 1.25538
R78 in2.t3 in2.t0 1.07826
R79 in2.t2 in2.n1 1.04409
R80 in1.t1 in1.n2 0.0251473
R81 in1.n6 in1.n0 13.5005
R82 in1.n5 in1.n6 7.5005
R83 in1.n10 in1.t5 5.5005
R84 in1.n8 in1.n3 3.17838
R85 in1.t0 in1.n10 3.17136
R86 in1.n10 in1.t6 2.64336
R87 in1.n3 in1.n4 2.32058
R88 in1.t3 in1.t4 1.54301
R89 in1.n5 in1.n7 1.5005
R90 in1.t3 in1.n0 1.34441
R91 in1.t3 in1.t0 1.17558
R92 in1.n4 in1.n7 1.14324
R93 in1.n8 in1.n7 0.785598
R94 in1.n9 in1.n8 0.5005
R95 in1.n9 in1.n6 0.5005
R96 in1.t1 in1.n5 0.5005
R97 in1.n1 in1.t1 0.0156763
R98 in1.t1 in1.n4 0.322839
R99 in1.n2 in1.n0 0.616409
R100 in1.n9 in1.n1 0.251526
R101 in1.n0 in1.t2 1.04852
R102 in1.n3 in1.n2 1.04106
R103 in1.n0 in1.n1 1.02936
R104 CLKb.n1 CLKb.t4 6.9132
R105 CLKb.n0 CLKb.t6 5.5005
R106 CLKb.n1 CLKb.t5 4.35764
R107 CLKb.n0 CLKb.t2 2.68859
R108 CLKb.n0 CLKb.t7 2.64336
R109 CLKb.t2 CLKb.n1 2.4531
R110 CLKb.t2 CLKb.t3 1.88858
R111 CLKb.t0 CLKb.n0 1.41006
R112 CLKb.t0 CLKb.t1 1.06397
C0 Q VDD 0.2889f
C1 out1 CLKN 0.59733f
C2 D VDD 0.2873f
C3 VDD QN 0.60489f
C4 a_2135_203r# out1 0.18322f
C5 Q QN 0.27986f
C6 VDD out1 0.7341f
C7 CLK CLKN 0.2677f
C8 VDD CLKN 1.44275f
C9 CLK VDD 0.43735f
C10 D CLKN 0.25041f
C11 QN VSS 1.58908f
C12 VDD VSS 16.09627f
C13 a_4107_203r# VSS 0.16271f
C14 a_2903_203r# VSS 0.72514f
C15 a_2135_203r# VSS 0.2771f
C16 a_945_203r# VSS 0.70565f
C17 out1 VSS 0.1654f
C18 CLKb.t0 VSS 1.61901f
C19 CLKb.n0 VSS 0.46189f
C20 CLKb.n1 VSS 0.37846f
C21 in1.t3 VSS 0.97289f
C22 in1.t2 VSS 0.24692f
C23 in1.n0 VSS 0.42439f
C24 in1.t1 VSS 0.25297f
C25 in1.t0 VSS 0.53081f
C26 in1.n10 VSS 0.1065f
C27 in2.t0 VSS 0.38483f
C28 in2.t3 VSS 0.46098f
C29 in2.n0 VSS 0.20546f
C30 in2.t2 VSS 0.71838f
C31 in2.n1 VSS 0.14871f
C32 out2.t1 VSS 1.75133f
C33 out2.t0 VSS 0.69483f
C34 out2.n0 VSS 0.58033f
C35 out2.n1 VSS 0.11586f
C36 a_828_987.t0 VSS 0.34456f
C37 a_828_987.t1 VSS 0.65527f
C38 a_2044_987.t0 VSS 0.41423f
C39 a_2044_987.t1 VSS 0.41525f
C40 a_2812_987.t0 VSS 1.15198f
C41 a_2812_987.t1 VSS 0.43402f
C42 a_4028_987.t1 VSS 0.59561f
C43 a_4028_987.t0 VSS 0.46827f
C44 VSS.t4 VSS 0.24485f
C45 VDD.t1 VSS 7.55418f
C46 Q.t1 VSS 0.14422f
C47 Q.n0 VSS 0.15858f
C48 Q.t0 VSS 0.16127f
C49 Q.n1 VSS 0.48666f
.ends
