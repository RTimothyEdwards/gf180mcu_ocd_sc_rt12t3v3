* NGSPICE file created from gf180mcu_ocd_sc_rt12t3v3__dlatn_1.ext - technology: gf180mcuD

.subckt gf180mcu_ocd_sc_rt12t3v3__dlatn_1 D CLK Q VDD VSS
X0 a_828_987.t1 CLKb.t4 in2.t1 VDD.t18 pfet_03v3 ad=0.5654p pd=3.45u as=0.3341p ps=1.805u w=1.285u l=0.28u
X1 out2 in2.t5 VDD VDD.t3 pfet_03v3 ad=0.3341p pd=1.805u as=0.5654p ps=3.45u w=1.285u l=0.28u
X2 Q.t0 a_2849_203r# VSS.t4 VSS.t3 nfet_03v3 ad=0.3087p pd=2.01u as=2.81442p ps=15.045u w=1.02u l=0.28u
X3 VDD.t7 out2 a_2849_203r# VDD.t17 pfet_03v3 ad=0.3341p pd=1.805u as=0.3341p ps=1.805u w=1.285u l=0.28u
X4 CLKN CLK.t1 VDD VDD.t4 pfet_03v3 ad=0.3341p pd=1.805u as=6.973p ps=42.83u w=1.285u l=0.28u
X5 VDD CLKN CLKb.t1 VDD.t10 pfet_03v3 ad=0.5654p pd=3.45u as=0.3341p ps=1.805u w=1.285u l=0.28u
X6 VDD D.t1 a_828_987.t0 VDD.t0 pfet_03v3 ad=0.3341p pd=1.805u as=0.5654p ps=3.45u w=1.285u l=0.28u
X7 VDD out2 a_2044_987.t0 VDD.t14 pfet_03v3 ad=0.3341p pd=1.805u as=0.5654p ps=3.45u w=1.285u l=0.28u
X8 a_2044_987.t1 CLKN in2.t2 VDD.t13 pfet_03v3 ad=0.5654p pd=3.45u as=0.3341p ps=1.805u w=1.285u l=0.28u
X9 a_2849_203r# out2 VDD.t7 VDD.t16 pfet_03v3 ad=0.3341p pd=1.805u as=0.5654p ps=3.45u w=1.285u l=0.28u
X10 a_913_203r# D VSS VSS.t0 nfet_03v3 ad=0.3087p pd=2.01u as=2.81442p ps=15.045u w=1.02u l=0.28u
X11 a_2044_987.t0 out2 VDD VDD.t15 pfet_03v3 ad=0.3341p pd=1.805u as=0.3341p ps=1.805u w=1.285u l=0.28u
X12 a_828_987.t1 D.t0 VDD VDD.t1 pfet_03v3 ad=0.3341p pd=1.805u as=0.3341p ps=1.805u w=1.285u l=0.28u
X13 CLKN CLK VSS VSS.t1 nfet_03v3 ad=0.3087p pd=2.01u as=2.81442p ps=15.045u w=1.02u l=0.28u
X14 VDD in2.t4 out2 VDD.t2 pfet_03v3 ad=0.5654p pd=3.45u as=0.3341p ps=1.805u w=1.285u l=0.28u
X15 Q.t1 a_2849_203r# VDD.t7 VDD.t7 pfet_03v3 ad=0.3341p pd=1.805u as=0.3341p ps=1.805u w=1.285u l=0.28u
X16 in2.t0 CLKb.t3 a_2091_203r# VSS.t5 nfet_03v3 ad=0.3087p pd=2.01u as=0.53235p ps=3.25u w=1.02u l=0.28u
X17 VDD CLK.t0 CLKN VDD pfet_03v3 ad=0.3341p pd=1.805u as=0.3341p ps=1.805u w=1.285u l=0.28u
X18 in2.t3 CLKN a_913_203r# VSS.t7 nfet_03v3 ad=0.3087p pd=2.01u as=0.52065p ps=3.23u w=1.02u l=0.28u
X19 VDD.t7 a_2849_203r# Q.t1 VDD.t8 pfet_03v3 ad=6.973p pd=42.83u as=0.3341p ps=1.805u w=1.285u l=0.28u
X20 a_2091_203r# out2 VSS VSS.t9 nfet_03v3 ad=0.3087p pd=2.01u as=2.41237p ps=12.895u w=1.02u l=0.28u
X21 a_2849_203r# out2 VSS.t4 VSS.t8 nfet_03v3 ad=0.3087p pd=2.01u as=2.41237p ps=12.895u w=1.02u l=0.28u
X22 CLKb.t0 CLKN VDD VDD.t11 pfet_03v3 ad=0.3341p pd=1.805u as=0.3341p ps=1.805u w=1.285u l=0.28u
X23 CLKb.t2 CLKN VSS VSS.t6 nfet_03v3 ad=0.3087p pd=2.01u as=2.81442p ps=15.045u w=1.02u l=0.28u
X24 in2.t2 CLKN a_2044_987.t0 VDD.t12 pfet_03v3 ad=0.3341p pd=1.805u as=0.3341p ps=1.805u w=1.285u l=0.28u
X25 out2 in2.t3 VSS VSS.t2 nfet_03v3 ad=0.3087p pd=2.015u as=2.81442p ps=15.045u w=1.02u l=0.28u
X26 in2.t1 CLKb.t5 a_828_987.t1 VDD.t9 pfet_03v3 ad=0.3341p pd=1.805u as=0.3341p ps=1.805u w=1.285u l=0.28u
R0 Q.n0 Q.n2 0.494649
R1 Q.n0 Q.t0 0.105869
R2 Q.n1 Q.t1 0.482703
R3 Q.n1 Q 0.271422
R4 Q.n1 Q.n0 1.29677
R5 D D.t0 4.29613
R6 D D.t1 3.2128
R7 CLK.n0 CLK.t0 5.5005
R8 CLK.n0 CLK.t1 2.64336
R9 CLK CLK.n0 1.39061
R10 VDD VDD.t4 26.843
R11 VDD VDD.t11 26.843
R12 VDD VDD.t0 26.843
R13 VDD.t7 VDD.t13 26.843
R14 VDD.t7 VDD.t17 26.843
R15 VDD.t7 VDD.t8 26.843
R16 VDD VDD.t9 22.3695
R17 VDD VDD.t18 22.3695
R18 VDD VDD.t3 22.3695
R19 VDD VDD.t2 22.3695
R20 VDD VDD.t14 22.3695
R21 VDD VDD.t15 22.3695
R22 VDD VDD.t10 13.4225
R23 VDD.t7 VDD.t12 13.4225
R24 VDD.t7 VDD.t16 13.4225
R25 VDD VDD.t1 13.4236
R26 VDD VDD.t7 1.10803
R27 VSS VSS.t0 490.481
R28 VSS.t4 VSS.t8 113.567
R29 VSS VSS.t7 128.171
R30 VSS VSS.t6 98.2424
R31 VSS VSS.t4 0.922339
R32 VSS.t0 VSS 22.9201
R33 VSS.t4 VSS.t5 17.6804
R34 VSS.t4 VSS 2.14767
R35 VSS.t4 VSS 1.91252
R36 VSS.t4 VSS 1.35991
R37 VSS.t4 VSS 1.20162
R38 VSS.t1 VSS 126.335
R39 VSS VSS.t9 126.334
R40 VSS.t4 VSS.t3 119.13
R41 VSS VSS.t2 75.3045
R42 a_2044_987.t1 a_2044_987.t0 1.907
R43 a_828_987.t1 a_828_987.t0 1.16186
R44 in2.n1 in2.t4 5.5005
R45 in2.t1 in2.n1 3.17136
R46 in2.n1 in2.t5 2.64336
R47 in2.t3 in2.t1 1.83962
R48 in2.n0 in2.t2 0.485968
R49 in2.t3 in2.t2 1.50869
R50 in2.t0 in2.t2 1.08315
R51 CLKb.n2 CLKb.t4 5.5005
R52 CLKb.n0 CLKb.n5 0.495596
R53 CLKb.n3 CLKb.t3 3.35558
R54 CLKb.n2 CLKb.t5 2.64336
R55 CLKb.n0 CLKb.t2 0.105456
R56 CLKb.n1 CLKb.n3 1.0314
R57 CLKb.n3 CLKb.n2 0.512929
R58 CLKb.n1 CLKb.n4 0.359276
R59 CLKb.n4 CLKb.t0 0.202835
R60 CLKb.n4 CLKb.t1 0.202835
R61 CLKb.n1 CLKb.n0 1.11436
C0 a_2849_203r# Q 0.25467f
C1 VDD a_2849_203r# 0.59346f
C2 a_2091_203r# out2 0.19769f
C3 out2 CLKN 0.36386f
C4 CLKN D 0.27322f
C5 CLKN CLK 0.2677f
C6 VDD CLKN 1.00774f
C7 VDD out2 0.94709f
C8 VDD D 0.2846f
C9 VDD Q 0.27823f
C10 VDD CLK 0.43735f
C11 a_2849_203r# out2 0.30841f
C12 VDD VSS 13.56816f
C13 a_2091_203r# VSS 0.48456f
C14 a_913_203r# VSS 0.98165f
C15 out2 VSS 0.68531f
C16 CLKb.n0 VSS 0.25083f
C17 CLKb.n1 VSS 0.31158f
C18 CLKb.n3 VSS 0.45014f
C19 CLKb.t1 VSS 0.51924f
C20 CLKb.n4 VSS 0.14481f
C21 CLKb.n5 VSS 0.15043f
C22 in2.t2 VSS 0.61999f
C23 in2.t0 VSS 0.53658f
C24 in2.t1 VSS 0.4783f
C25 a_828_987.t0 VSS 0.34582f
C26 a_828_987.t1 VSS 0.65626f
C27 a_2044_987.t0 VSS 0.39338f
C28 a_2044_987.t1 VSS 0.39435f
C29 VSS.t4 VSS 0.2409f
C30 VDD.t7 VSS 2.35333f
C31 Q.t0 VSS 0.27692f
C32 Q.n0 VSS 0.15057f
C33 Q.t1 VSS 0.31209f
C34 Q.n1 VSS 0.41616f
.ends
