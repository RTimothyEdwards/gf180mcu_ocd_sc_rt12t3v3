* NGSPICE file created from gf180mcu_ocd_sc_rt12t3v3__tinv_1.ext - technology: gf180mcuD

.subckt gf180mcu_ocd_sc_rt12t3v3__tinv_1 A EN Y VDD VSS
X0 Y.t0 EN.t0 a_181_203r# VSS.t0 nfet_03v3 ad=0.3087p pd=2.01u as=0.52065p ps=3.23u w=1.02u l=0.28u
X1 a_92_987.t1 A.t0 VDD VDD.t3 pfet_03v3 ad=0.3341p pd=1.805u as=0.3341p ps=1.805u w=1.285u l=0.28u
X2 VDD EN.t1 EN_BAR.t1 VDD.t1 pfet_03v3 ad=0.5654p pd=3.45u as=0.3341p ps=1.805u w=1.285u l=0.28u
X3 Y EN_BAR.t4 a_92_987.t1 VDD.t5 pfet_03v3 ad=0.3341p pd=1.805u as=0.3341p ps=1.805u w=1.285u l=0.28u
X4 EN_BAR.t2 EN VSS VSS.t1 nfet_03v3 ad=0.3087p pd=2.01u as=3.57195p ps=19.96u w=1.02u l=0.28u
X5 VDD A.t1 a_92_987.t0 VDD.t2 pfet_03v3 ad=0.3341p pd=1.805u as=0.5654p ps=3.45u w=1.285u l=0.28u
X6 a_92_987.t1 EN_BAR.t3 Y VDD.t4 pfet_03v3 ad=0.5654p pd=3.45u as=0.3341p ps=1.805u w=1.285u l=0.28u
X7 EN_BAR.t0 EN.t2 VDD VDD.t0 pfet_03v3 ad=0.3341p pd=1.805u as=0.5654p ps=3.45u w=1.285u l=0.28u
X8 a_181_203r# A VSS VSS.t2 nfet_03v3 ad=0.3087p pd=2.01u as=3.57195p ps=19.96u w=1.02u l=0.28u
R0 Y Y.t0 1.1483
R1 EN EN.t2 6.91277
R2 EN EN.t1 4.23264
R3 EN EN.t0 1.54222
R4 A A.t0 4.26836
R5 A A.t1 3.24058
R6 VDD VDD.t3 22.3695
R7 VDD VDD.t5 22.3695
R8 VDD VDD.t0 22.3695
R9 VDD VDD.t2 14.5409
R10 VDD VDD.t4 13.4225
R11 VDD VDD.t1 13.4225
R12 VSS VSS.t0 9.0049
R13 VSS VSS.t2 190.2
R14 VSS VSS.t1 128.298
R15 a_92_987.t1 a_92_987.t0 1.16186
R16 EN_BAR.n2 EN_BAR.t4 5.6142
R17 EN_BAR.n0 EN_BAR.n4 0.495596
R18 EN_BAR.n2 EN_BAR.t3 2.70969
R19 EN_BAR.n0 EN_BAR.t2 0.105456
R20 EN_BAR.n1 EN_BAR.n2 0.86691
R21 EN_BAR.n1 EN_BAR.n3 0.259891
R22 EN_BAR.n3 EN_BAR.t0 0.202835
R23 EN_BAR.n3 EN_BAR.t1 0.202835
R24 EN_BAR.n1 EN_BAR.n0 1.64938
C0 A VDD 0.38298f
C1 EN Y 0.10125f
C2 VDD EN 0.41758f
C3 Y VSS 0.36045f
C4 VDD VSS 6.01157f
C5 a_181_203r# VSS 0.73892f
C6 EN_BAR.t2 VSS 0.76216f
C7 EN_BAR.n0 VSS 0.23616f
C8 EN_BAR.n1 VSS 0.2545f
C9 EN_BAR.n2 VSS 0.11037f
C10 EN_BAR.n3 VSS 0.11645f
C11 EN_BAR.n4 VSS 0.13087f
C12 a_92_987.t0 VSS 0.31974f
C13 a_92_987.t1 VSS 0.60465f
C14 Y.t0 VSS 0.34766f
.ends
