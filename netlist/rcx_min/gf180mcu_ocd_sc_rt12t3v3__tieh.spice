* NGSPICE file created from gf180mcu_ocd_sc_rt12t3v3__tieh.ext - technology: gf180mcuD

.subckt gf180mcu_ocd_sc_rt12t3v3__tieh Y VDD VSS
X0 VDD a_93_147# Y VDD.t1 pfet_03v3 ad=2.7424p pd=12.83u as=0.3341p ps=1.805u w=1.285u l=0.28u
X1 Y a_93_147# VDD VDD.t0 pfet_03v3 ad=0.3341p pd=1.805u as=2.7424p ps=12.83u w=1.285u l=0.28u
X2 a_93_147# a_93_147# VSS VSS.t0 nfet_03v3 ad=0.3087p pd=2.01u as=4.22095p ps=23.13u w=1.02u l=0.28u
R0 VDD VDD.t1 22.3695
R1 VDD VDD.t0 13.4225
R2 VSS VSS.t0 111.486
C0 VDD a_93_147# 0.36302f
C1 a_93_147# Y 0.18783f
C2 VDD Y 0.27703f
C3 Y VSS 0.47294f
C4 VDD VSS 3.1007f
.ends
