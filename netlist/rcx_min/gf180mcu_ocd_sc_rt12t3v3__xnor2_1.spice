* NGSPICE file created from gf180mcu_ocd_sc_rt12t3v3__xnor2_1.ext - technology: gf180mcuD

.subckt gf180mcu_ocd_sc_rt12t3v3__xnor2_1 A B Y VDD VSS
X0 VDD A.t4 AN.t0 VDD.t1 pfet_03v3 ad=0.5654p pd=3.45u as=0.3341p ps=1.805u w=1.285u l=0.28u
X1 VDD AN.t2 a_1313_987.t1 VDD.t11 pfet_03v3 ad=0.3341p pd=1.805u as=0.5654p ps=3.45u w=1.285u l=0.28u
X2 Y.t0 A.t3 a_540_987.t0 VDD.t2 pfet_03v3 ad=0.3341p pd=1.805u as=0.5654p ps=3.45u w=1.285u l=0.28u
X3 a_830_145# AN Y VSS.t5 nfet_03v3 ad=0.52065p pd=3.23u as=0.3087p ps=2.01u w=1.02u l=0.28u
X4 a_540_987.t1 B.t4 VDD VDD.t6 pfet_03v3 ad=0.5654p pd=3.45u as=0.3341p ps=1.805u w=1.285u l=0.28u
X5 a_1313_987.t0 AN.t1 VDD VDD.t8 pfet_03v3 ad=0.3341p pd=1.805u as=0.3341p ps=1.805u w=1.285u l=0.28u
X6 AN A.t1 VSS VSS.t0 nfet_03v3 ad=0.3087p pd=2.01u as=4.00512p ps=22.26u w=1.02u l=0.28u
X7 a_540_987.t0 A.t2 Y.t0 VDD.t3 pfet_03v3 ad=0.3341p pd=1.805u as=0.3341p ps=1.805u w=1.285u l=0.28u
X8 BN.t0 B.t0 VSS VSS.t0 nfet_03v3 ad=0.3087p pd=2.01u as=4.00512p ps=22.26u w=1.02u l=0.28u
X9 a_1411_203r# A.t0 VSS VSS.t0 nfet_03v3 ad=0.3087p pd=2.015u as=4.00512p ps=22.26u w=1.02u l=0.28u
X10 BN.t1 B.t3 VDD VDD.t4 pfet_03v3 ad=0.3341p pd=1.805u as=0.5654p ps=3.45u w=1.285u l=0.28u
X11 AN.t0 A.t5 VDD VDD.t0 pfet_03v3 ad=0.3341p pd=1.805u as=0.5654p ps=3.45u w=1.285u l=0.28u
X12 Y.t2 BN.t4 a_1313_987.t0 VDD.t9 pfet_03v3 ad=0.3341p pd=1.805u as=0.3341p ps=1.805u w=1.285u l=0.28u
X13 Y.t1 BN.t2 a_1411_203r# VSS.t4 nfet_03v3 ad=0.3087p pd=2.01u as=0.52065p ps=3.23u w=1.02u l=0.28u
X14 VDD B.t5 a_540_987.t0 VDD.t5 pfet_03v3 ad=0.3341p pd=1.805u as=0.3341p ps=1.805u w=1.285u l=0.28u
X15 a_830_145# B.t1 VSS VSS.t0 nfet_03v3 ad=0.3087p pd=2.01u as=4.00512p ps=22.26u w=1.02u l=0.28u
X16 a_1313_987.t0 BN.t3 Y.t2 VDD.t10 pfet_03v3 ad=0.5654p pd=3.45u as=0.3341p ps=1.805u w=1.285u l=0.28u
X17 VDD B.t2 BN.t1 VDD.t7 pfet_03v3 ad=0.5654p pd=3.45u as=0.3341p ps=1.805u w=1.285u l=0.28u
R0 Y.t2 Y 18.5445
R1 Y.t2 Y.t0 1.4003
R2 Y.t1 Y.t2 1.24929
R3 Y.t2 Y 1.08719
R4 B.n0 B.t5 6.05209
R5 B B.t3 5.43812
R6 B B.t2 5.21894
R7 B.n0 B.t4 4.88542
R8 B B.n0 1.73714
R9 B.n0 B.t1 1.38972
R10 B B.t0 1.09399
R11 A.n0 A.t2 5.69385
R12 A A.t4 5.43812
R13 A A.t5 5.21894
R14 A.n0 A.t3 2.6689
R15 A A.n0 1.65355
R16 A.t0 A 2.56522
R17 A A.t1 1.18897
R18 VDD VDD.t9 25.9256
R19 VDD VDD.t1 22.3695
R20 VDD VDD.t3 22.3695
R21 VDD VDD.t5 22.3695
R22 VDD VDD.t4 22.3695
R23 VDD VDD.t11 20.0541
R24 VDD VDD.t8 16.699
R25 VDD VDD.t2 13.4225
R26 VDD VDD.t6 13.4225
R27 VDD VDD.t10 4.67644
R28 VDD VDD.t7 13.4225
R29 VDD VDD.t0 13.4225
R30 VSS VSS.t4 70.3019
R31 VSS VSS.t0 56.5548
R32 VSS.t4 VSS.t5 1.15298
R33 VSS.t5 VSS.t0 1.15298
R34 a_1313_987.t0 a_1313_987.t1 1.16186
R35 a_540_987.t0 a_540_987.t1 1.16186
R36 BN.n0 BN.t4 5.37748
R37 BN.n0 BN.t3 2.64336
R38 BN.t0 BN.t2 1.38763
R39 BN BN.t0 1.26725
R40 BN BN.t1 1.1412
R41 BN.t0 BN.n0 1.09882
R42 AN.n1 AN.t1 4.26836
R43 AN.n1 AN.t2 3.24058
R44 AN.n0 AN.n1 1.9676
R45 AN AN.n0 1.48796
R46 AN AN.t0 1.1412
C0 A B 0.25313f
C1 VDD B 0.88953f
C2 Y B 0.30075f
C3 BN VDD 0.62667f
C4 AN A 0.74059f
C5 AN VDD 0.63695f
C6 Y BN 0.23018f
C7 VDD A 0.7712f
C8 BN B 0.6351f
C9 Y AN 0.23348f
C10 Y A 0.36158f
C11 Y VDD 0.19874f
C12 AN B 0.35513f
C13 Y VSS 0.79191f
C14 B VSS 1.54439f
C15 A VSS 1.81711f
C16 VDD VSS 11.11427f
C17 a_1411_203r# VSS 0.46224f
C18 a_830_145# VSS 0.86906f
C19 BN VSS 1.05858f
C20 AN VSS 0.1632f
C21 AN.n0 VSS 1.03353f
C22 AN.t0 VSS 0.39948f
C23 AN.n1 VSS 0.34868f
C24 BN.t0 VSS 0.73834f
C25 BN.t1 VSS 0.32875f
C26 BN.n0 VSS 0.16202f
C27 a_540_987.t1 VSS 0.36013f
C28 a_540_987.t0 VSS 0.6589f
C29 a_1313_987.t1 VSS 0.3559f
C30 a_1313_987.t0 VSS 0.63944f
C31 A.n0 VSS 0.11827f
C32 B.n0 VSS 0.59985f
C33 Y.t2 VSS 1.4599f
C34 Y.t0 VSS 0.21818f
C35 Y.t1 VSS 0.35983f
.ends
