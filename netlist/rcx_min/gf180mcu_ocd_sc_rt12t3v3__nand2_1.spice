* NGSPICE file created from gf180mcu_ocd_sc_rt12t3v3__nand2_1.ext - technology: gf180mcuD

.subckt gf180mcu_ocd_sc_rt12t3v3__nand2_1 A B Y VDD VSS
X0 Y.t1 A.t0 a_193_203r# VSS.t1 nfet_03v3 ad=0.3087p pd=2.01u as=0.52065p ps=3.23u w=1.02u l=0.28u
X1 VDD B.t1 Y.t2 VDD.t1 pfet_03v3 ad=0.3341p pd=1.805u as=0.3341p ps=1.805u w=1.285u l=0.28u
X2 Y.t0 A.t2 VDD VDD.t2 pfet_03v3 ad=0.3341p pd=1.805u as=0.3341p ps=1.805u w=1.285u l=0.28u
X3 Y.t2 B.t2 VDD VDD.t0 pfet_03v3 ad=0.3341p pd=1.805u as=0.5654p ps=3.45u w=1.285u l=0.28u
X4 VDD A.t1 Y.t0 VDD.t3 pfet_03v3 ad=0.5654p pd=3.45u as=0.3341p ps=1.805u w=1.285u l=0.28u
X5 a_193_203r# B.t0 VSS VSS.t0 nfet_03v3 ad=0.3087p pd=2.01u as=5.19535p ps=29.85u w=1.02u l=0.28u
R0 Y.n4 Y.n3 0.438012
R1 Y.n6 Y 13.5005
R2 Y.n3 Y.n0 0.473603
R3 Y.n2 Y.t1 0.244071
R4 Y.n4 Y.n5 3.45801
R5 Y.n1 Y.n4 1.3794
R6 Y Y.t0 1.26854
R7 Y.n1 Y.t1 0.182806
R8 Y.n2 Y 1.09651
R9 Y Y.n0 0.840305
R10 Y.t0 Y.t2 0.837269
R11 Y.n5 Y.n2 0.497024
R12 Y.t1 Y.n0 0.0651001
R13 Y.n6 Y.n3 0.5005
R14 Y.n1 Y.n6 7.73964
R15 A.n0 A.t1 5.5005
R16 A.n0 A.t2 2.64336
R17 A.n0 A.t0 1.7372
R18 A A.t0 0.0005
R19 B.n0 B.t1 5.5005
R20 B.n0 B.t2 2.64336
R21 B.n0 B.t0 1.51677
R22 B B.t0 0.0005
R23 VDD VDD.t1 22.3695
R24 VDD VDD.t2 22.3695
R25 VDD VDD.t3 13.4225
R26 VDD VDD.t0 13.4225
R27 VSS.t0 VSS 121.422
R28 VSS VSS.t1 41.869
C0 A Y 0.31338f
C1 Y VDD 0.43838f
C2 B VDD 0.36689f
C3 A VDD 0.31804f
C4 Y VSS 0.36217f
C5 A VSS 0.47679f
C6 B VSS 0.53988f
C7 VDD VSS 4.18094f
C8 a_193_203r# VSS 0.39682f
C9 B.n0 VSS 0.18653f
C10 A.n0 VSS 0.23441f
C11 Y.t1 VSS 0.22678f
C12 Y.t0 VSS 0.37293f
C13 Y.t2 VSS 0.18329f
.ends
