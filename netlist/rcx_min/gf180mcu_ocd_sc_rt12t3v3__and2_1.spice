* NGSPICE file created from gf180mcu_ocd_sc_rt12t3v3__and2_1.ext - technology: gf180mcuD

.subckt gf180mcu_ocd_sc_rt12t3v3__and2_1 A B Y VDD VSS
X0 a_236_987.t1 A.t0 a_193_203r# VSS.t1 nfet_03v3 ad=0.3087p pd=2.015u as=0.52065p ps=3.23u w=1.02u l=0.28u
X1 VDD B.t1 a_236_987.t0 VDD.t1 pfet_03v3 ad=0.3341p pd=1.805u as=0.3341p ps=1.805u w=1.285u l=0.28u
X2 Y.t0 a_236_987.t4 VDD VDD.t4 pfet_03v3 ad=0.3341p pd=1.805u as=0.3341p ps=1.805u w=1.285u l=0.28u
X3 VDD a_236_987.t3 Y.t0 VDD pfet_03v3 ad=0.5654p pd=3.45u as=0.3341p ps=1.805u w=1.285u l=0.28u
X4 a_236_987.t1 A.t2 VDD VDD.t2 pfet_03v3 ad=0.3341p pd=1.805u as=0.3341p ps=1.805u w=1.285u l=0.28u
X5 a_236_987.t0 B.t2 VDD VDD.t0 pfet_03v3 ad=0.3341p pd=1.805u as=0.5654p ps=3.45u w=1.285u l=0.28u
X6 VDD A.t1 a_236_987.t1 VDD.t3 pfet_03v3 ad=0.3341p pd=1.805u as=0.3341p ps=1.805u w=1.285u l=0.28u
X7 a_193_203r# B.t0 VSS VSS.t0 nfet_03v3 ad=0.3087p pd=2.01u as=3.40955p ps=18.84u w=1.02u l=0.28u
X8 Y.t1 a_236_987.t2 VSS VSS.t2 nfet_03v3 ad=0.3087p pd=2.01u as=3.40955p ps=18.84u w=1.02u l=0.28u
R0 Y.n0 Y.n2 0.494649
R1 Y.n0 Y.t1 0.105869
R2 Y.n1 Y.t0 0.528189
R3 Y.n1 Y 0.208002
R4 Y.n1 Y.n0 1.05343
R5 A.n0 A.t1 5.5005
R6 A.n0 A.t2 2.64336
R7 A.t0 A.n0 1.75874
R8 A A.t0 0.0005
R9 B.n0 B.t1 5.5005
R10 B.n0 B.t2 2.64336
R11 B.n0 B.t0 1.54812
R12 B B.t0 0.0005
R13 VDD VDD.t4 26.843
R14 VDD VDD.t1 22.3695
R15 VDD VDD.t2 22.3695
R16 VDD VDD.t3 13.4236
R17 VDD VDD.t0 13.4225
R18 VSS VSS.t2 121.424
R19 VSS.t0 VSS 121.422
R20 VSS VSS.t1 41.7428
R21 a_236_987.t1 a_236_987.t3 5.5005
R22 a_236_987.t1 a_236_987.t4 2.64336
R23 a_236_987.t1 a_236_987.t0 2.26756
R24 a_236_987.t1 a_236_987.t2 1.78878
C0 VDD B 0.36677f
C1 VDD A 0.31498f
C2 Y VDD 0.28428f
C3 A VSS 0.41604f
C4 B VSS 0.53071f
C5 VDD VSS 5.52914f
C6 a_193_203r# VSS 0.41009f
C7 a_236_987.t0 VSS 0.28326f
C8 a_236_987.t1 VSS 1.0825f
C9 B.n0 VSS 0.18738f
C10 A.n0 VSS 0.25353f
C11 Y.t1 VSS 0.11267f
C12 Y.n0 VSS 0.14565f
C13 Y.t0 VSS 0.15125f
C14 Y.n1 VSS 0.44439f
.ends
