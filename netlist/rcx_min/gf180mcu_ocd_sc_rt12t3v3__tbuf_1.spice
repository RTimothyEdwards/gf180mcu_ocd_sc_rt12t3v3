* NGSPICE file created from gf180mcu_ocd_sc_rt12t3v3__tbuf_1.ext - technology: gf180mcuD

.subckt gf180mcu_ocd_sc_rt12t3v3__tbuf_1 A EN Y VDD VSS
X0 EN_BAR.t0 EN.t3 VDD VDD.t1 pfet_03v3 ad=0.3341p pd=1.805u as=0.5654p ps=3.45u w=1.285u l=0.28u
X1 a_211_203r# A.t0 VSS VSS.t2 nfet_03v3 ad=0.3087p pd=2.01u as=3.0308p ps=16.66u w=1.02u l=0.28u
X2 VDD A.t1 a_211_203r# VDD.t4 pfet_03v3 ad=0.5654p pd=3.45u as=0.3341p ps=1.805u w=1.285u l=0.28u
X3 VDD a_211_203r# a_540_987.t1 VDD.t7 pfet_03v3 ad=0.3341p pd=1.805u as=0.5654p ps=3.45u w=1.285u l=0.28u
X4 Y.t0 EN.t1 a_629_203r# VSS.t0 nfet_03v3 ad=0.3087p pd=2.01u as=0.52065p ps=3.23u w=1.02u l=0.28u
X5 a_540_987.t0 EN_BAR.t3 Y VDD.t6 pfet_03v3 ad=0.5654p pd=3.45u as=0.3341p ps=1.805u w=1.285u l=0.28u
X6 a_540_987.t0 a_211_203r# VDD VDD.t8 pfet_03v3 ad=0.3341p pd=1.805u as=0.3341p ps=1.805u w=1.285u l=0.28u
X7 VDD EN.t2 EN_BAR.t1 VDD.t0 pfet_03v3 ad=0.5654p pd=3.45u as=0.3341p ps=1.805u w=1.285u l=0.28u
X8 a_211_203r# A.t2 VDD.t3 VDD.t2 pfet_03v3 ad=0.3341p pd=1.805u as=0.5654p ps=3.45u w=1.285u l=0.28u
X9 Y EN_BAR.t4 a_540_987.t0 VDD.t5 pfet_03v3 ad=0.3341p pd=1.805u as=0.3341p ps=1.805u w=1.285u l=0.28u
X10 EN_BAR.t2 EN.t0 VSS VSS.t1 nfet_03v3 ad=0.3087p pd=2.01u as=3.0308p ps=16.66u w=1.02u l=0.28u
X11 a_629_203r# a_211_203r# VSS VSS.t3 nfet_03v3 ad=0.3087p pd=2.01u as=3.0308p ps=16.66u w=1.02u l=0.28u
R0 Y Y.t0 1.1483
R1 EN.n0 EN.t3 5.43812
R2 EN.n0 EN.t2 5.21894
R3 EN.n1 EN.t0 0.695375
R4 EN.n2 EN.n1 0.399119
R5 EN EN.n2 0.32753
R6 EN.n2 EN.n0 0.285182
R7 EN.n1 EN.t1 1.048
R8 A.n0 A.t1 5.50248
R9 A.n0 A.t2 4.8636
R10 A.t0 A.n0 1.47788
R11 A A.n0 0.0005
R12 VDD VDD.t4 22.3695
R13 VDD VDD.t8 22.3695
R14 VDD VDD.t5 22.3695
R15 VDD VDD.t1 22.3695
R16 VDD VDD.t7 13.4225
R17 VDD VDD.t6 13.4225
R18 VDD VDD.t0 13.4225
R19 VDD VDD.t2 13.4225
R20 VDD VDD.t3 1.14898
R21 VSS VSS.t0 9.0049
R22 VSS VSS.t2 89.0103
R23 VSS VSS.t1 128.298
R24 VSS VSS.t3 128.298
R25 a_540_987.t1 a_540_987.t0 1.907
R26 EN_BAR.n2 EN_BAR.t4 5.6846
R27 EN_BAR.n0 EN_BAR.n4 0.495596
R28 EN_BAR.n2 EN_BAR.t3 2.67021
R29 EN_BAR.n1 EN_BAR.n2 1.53831
R30 EN_BAR.n0 EN_BAR.t2 0.105456
R31 EN_BAR.n1 EN_BAR.n3 0.259891
R32 EN_BAR.n3 EN_BAR.t0 0.202835
R33 EN_BAR.n3 EN_BAR.t1 0.202835
R34 EN_BAR.n1 EN_BAR.n0 1.64938
C0 EN Y 0.10138f
C1 EN VDD 0.42562f
C2 VDD a_211_203r# 0.57095f
C3 A a_211_203r# 0.27635f
C4 VDD A 0.44926f
C5 Y VSS 0.36705f
C6 EN VSS 0.84879f
C7 A VSS 0.53131f
C8 VDD VSS 8.06209f
C9 a_629_203r# VSS 0.18567f
C10 EN_BAR.t2 VSS 0.12612f
C11 EN_BAR.n0 VSS 0.24973f
C12 EN_BAR.n1 VSS 0.31501f
C13 EN_BAR.n2 VSS 0.11615f
C14 EN_BAR.n3 VSS 0.12315f
C15 EN_BAR.n4 VSS 0.13839f
C16 a_540_987.t0 VSS 0.48646f
C17 a_540_987.t1 VSS 0.72592f
C18 A.n0 VSS 0.33783f
C19 EN.n0 VSS 0.1124f
C20 EN.n1 VSS 0.30255f
C21 Y.t0 VSS 0.34415f
.ends
