* NGSPICE file created from gf180mcu_ocd_sc_rt12t3v3__dffn_1.ext - technology: gf180mcuD

.subckt gf180mcu_ocd_sc_rt12t3v3__dffn_1 D CLKN Q QN VDD VSS
X0 a_828_987.t1 CLK in1.t3 VDD.t18 pfet_03v3 ad=0.5654p pd=3.45u as=0.3341p ps=1.805u w=1.285u l=0.28u
X1 out1 in1.t6 VDD.t1 VDD.t9 pfet_03v3 ad=0.3341p pd=1.805u as=0.5654p ps=3.45u w=1.285u l=0.28u
X2 a_2812_987.t0 out1 VDD.t1 VDD.t26 pfet_03v3 ad=0.3341p pd=1.805u as=0.3341p ps=1.805u w=1.285u l=0.28u
X3 a_4028_987.t0 out2.t6 VDD.t1 VDD.t5 pfet_03v3 ad=0.3341p pd=1.805u as=0.3341p ps=1.805u w=1.285u l=0.28u
X4 CLK CLKN.t1 VDD VDD.t27 pfet_03v3 ad=0.3341p pd=1.805u as=19.0728p ps=0.12486m w=1.285u l=0.28u
X5 VDD.t1 CLK CLKNb.t1 VDD.t16 pfet_03v3 ad=0.5654p pd=3.45u as=0.3341p ps=1.805u w=1.285u l=0.28u
X6 VDD.t1 D.t1 a_828_987.t0 VDD.t0 pfet_03v3 ad=0.3341p pd=1.805u as=0.5654p ps=3.45u w=1.285u l=0.28u
X7 out2.t1 in2.t4 VDD.t1 VDD.t12 pfet_03v3 ad=0.5654p pd=3.45u as=0.3341p ps=1.805u w=1.285u l=0.28u
X8 in1.t0 CLKNb.t3 a_945_203r# VSS.t6 nfet_03v3 ad=0.3087p pd=2.01u as=0.52065p ps=3.23u w=1.02u l=0.28u
X9 VDD.t1 out1 a_2044_987.t1 VDD.t24 pfet_03v3 ad=0.3341p pd=1.805u as=0.5654p ps=3.45u w=1.285u l=0.28u
X10 a_2044_987.t0 CLKNb.t6 in1.t1 VDD.t8 pfet_03v3 ad=0.5654p pd=3.45u as=0.3341p ps=1.805u w=1.285u l=0.28u
X11 VDD.t1 out1 a_2812_987.t1 VDD.t23 pfet_03v3 ad=0.3341p pd=1.805u as=0.5654p ps=3.45u w=1.285u l=0.28u
X12 Q.t0 QN.t2 VDD.t1 VDD.t21 pfet_03v3 ad=0.3341p pd=1.805u as=0.3341p ps=1.805u w=1.285u l=0.28u
X13 QN out2.t2 VSS.t2 VSS.t1 nfet_03v3 ad=0.3087p pd=2.01u as=2.74232p ps=14.88u w=1.02u l=0.28u
X14 a_2044_987.t0 out1 VDD.t1 VDD.t25 pfet_03v3 ad=0.3341p pd=1.805u as=0.3341p ps=1.805u w=1.285u l=0.28u
X15 in2.t2 CLK a_2903_203r# VSS.t10 nfet_03v3 ad=0.3087p pd=2.01u as=0.52065p ps=3.23u w=1.02u l=0.28u
X16 Q.t1 QN.t0 VSS.t2 VSS.t11 nfet_03v3 ad=0.3087p pd=2.01u as=3.08512p ps=16.74u w=1.02u l=0.28u
X17 a_2135_203r# out1 VSS VSS.t13 nfet_03v3 ad=0.3087p pd=2.01u as=2.74232p ps=14.88u w=1.02u l=0.28u
X18 a_2903_203r# out1 VSS VSS.t12 nfet_03v3 ad=0.3087p pd=2.01u as=2.74232p ps=14.88u w=1.02u l=0.28u
X19 a_828_987.t1 D.t0 VDD.t1 VDD.t2 pfet_03v3 ad=0.3341p pd=1.805u as=0.3341p ps=1.805u w=1.285u l=0.28u
X20 CLK CLKN VSS VSS.t14 nfet_03v3 ad=0.3087p pd=2.01u as=3.08512p ps=16.74u w=1.02u l=0.28u
X21 out1 in1.t4 VSS VSS.t7 nfet_03v3 ad=0.3087p pd=2.015u as=3.08512p ps=16.74u w=1.02u l=0.28u
X22 VDD.t1 in1.t5 out1 VDD.t4 pfet_03v3 ad=0.5654p pd=3.45u as=0.3341p ps=1.805u w=1.285u l=0.28u
X23 VDD.t1 QN.t1 Q.t0 VDD.t22 pfet_03v3 ad=0.5654p pd=3.45u as=0.3341p ps=1.805u w=1.285u l=0.28u
X24 in2.t3 CLK a_4028_987.t0 VDD.t19 pfet_03v3 ad=0.3341p pd=1.805u as=0.3341p ps=1.805u w=1.285u l=0.28u
X25 in2.t0 CLKNb.t5 a_2812_987.t0 VDD.t1 pfet_03v3 ad=0.3341p pd=1.805u as=0.3341p ps=1.805u w=1.285u l=0.28u
X26 VDD.t15 CLKN.t0 CLK VDD pfet_03v3 ad=0.3341p pd=1.805u as=0.3341p ps=1.805u w=1.285u l=0.28u
X27 in1.t2 CLK a_2135_203r# VSS.t9 nfet_03v3 ad=0.3087p pd=2.01u as=0.52065p ps=3.23u w=1.02u l=0.28u
X28 a_4028_987.t0 CLK in2.t3 VDD.t20 pfet_03v3 ad=0.5654p pd=3.45u as=0.3341p ps=1.805u w=1.285u l=0.28u
X29 a_2812_987.t0 CLKNb.t4 in2.t0 VDD.t3 pfet_03v3 ad=0.5654p pd=3.45u as=0.3341p ps=1.805u w=1.285u l=0.28u
X30 QN out2.t5 VDD.t1 VDD.t7 pfet_03v3 ad=0.3341p pd=1.805u as=0.5654p ps=3.45u w=1.285u l=0.28u
X31 CLKNb.t1 CLK VDD.t15 VDD.t14 pfet_03v3 ad=0.3341p pd=1.805u as=0.3341p ps=1.805u w=1.285u l=0.28u
X32 CLKNb.t0 CLK VSS VSS.t8 nfet_03v3 ad=0.3087p pd=2.01u as=3.08512p ps=16.74u w=1.02u l=0.28u
X33 VDD.t1 in2.t5 out2.t1 VDD.t1 pfet_03v3 ad=0.3341p pd=1.805u as=0.5654p ps=3.45u w=1.285u l=0.28u
X34 in1.t1 CLKNb.t7 a_2044_987.t0 VDD.t10 pfet_03v3 ad=0.3341p pd=1.805u as=0.3341p ps=1.805u w=1.285u l=0.28u
X35 in1.t3 CLK a_828_987.t1 VDD.t17 pfet_03v3 ad=0.3341p pd=1.805u as=0.3341p ps=1.805u w=1.285u l=0.28u
X36 VDD.t1 out2.t4 QN VDD.t6 pfet_03v3 ad=0.3341p pd=1.805u as=0.3341p ps=1.805u w=1.285u l=0.28u
X37 in2.t1 CLKNb.t2 a_4107_203r# VSS.t5 nfet_03v3 ad=0.3087p pd=2.01u as=0.53235p ps=3.25u w=1.02u l=0.28u
X38 a_945_203r# D VSS VSS.t0 nfet_03v3 ad=0.3087p pd=2.01u as=3.08512p ps=16.74u w=1.02u l=0.28u
X39 VDD.t1 out2.t7 a_4028_987.t1 VDD.t1 pfet_03v3 ad=0.3341p pd=1.805u as=0.5654p ps=3.45u w=1.285u l=0.28u
X40 out2.t0 in2.t2 VSS VSS.t4 nfet_03v3 ad=0.3087p pd=2.015u as=3.08512p ps=16.74u w=1.02u l=0.28u
X41 a_4107_203r# out2.t3 VSS VSS.t3 nfet_03v3 ad=0.3087p pd=2.01u as=2.74232p ps=14.88u w=1.02u l=0.28u
R0 Q.n0 Q.n2 0.494649
R1 Q.n0 Q.t1 0.105869
R2 Q.n1 Q.t0 0.47979
R3 Q.n1 Q 0.232891
R4 Q.n1 Q.n0 1.29677
R5 QN QN.t1 5.71875
R6 QN QN.t2 5.21875
R7 QN QN.t0 1.22658
R8 D D.t0 4.29613
R9 D D.t1 3.2128
R10 CLKN.n0 CLKN.t0 5.5005
R11 CLKN.n0 CLKN.t1 2.64336
R12 CLKN CLKN.n0 1.39061
R13 VDD VDD.t27 26.843
R14 VDD VDD.t14 26.843
R15 VDD.t1 VDD.t0 26.843
R16 VDD.t1 VDD.t8 26.843
R17 VDD.t1 VDD.t26 26.843
R18 VDD.t1 VDD.t3 26.843
R19 VDD.t1 VDD.t12 26.843
R20 VDD.t1 VDD.t5 26.843
R21 VDD.t1 VDD.t17 22.3695
R22 VDD.t1 VDD.t18 22.3695
R23 VDD.t1 VDD.t9 22.3695
R24 VDD.t1 VDD.t4 22.3695
R25 VDD.t1 VDD.t24 22.3695
R26 VDD.t1 VDD.t25 22.3695
R27 VDD.t1 VDD.t20 22.3695
R28 VDD.t1 VDD.t6 22.3695
R29 VDD.t1 VDD.t21 22.3695
R30 VDD.t1 VDD.t16 13.4225
R31 VDD.t1 VDD.t10 13.4225
R32 VDD.t1 VDD.t19 13.4225
R33 VDD.t1 VDD.t23 13.4236
R34 VDD.t1 VDD.t2 13.4236
R35 VDD VDD.t15 0.46667
R36 VDD.t1 VDD.t7 13.4225
R37 VDD.t1 VDD.t22 13.4225
R38 VDD VDD.t1 1.3464
R39 VSS VSS.t7 49.11
R40 VSS VSS.t0 113.566
R41 VSS.t2 VSS.t1 113.567
R42 VSS VSS.t2 128.339
R43 VSS VSS.t9 125.716
R44 VSS VSS.t10 104.763
R45 VSS VSS.t8 98.2424
R46 VSS VSS.t6 81.0283
R47 VSS VSS.t5 17.6804
R48 VSS.t2 VSS 3.42447
R49 VSS.t2 VSS 3.18932
R50 VSS.t2 VSS 2.22554
R51 VSS.t2 VSS 2.06724
R52 VSS VSS.t13 21.8958
R53 VSS.t14 VSS 126.335
R54 VSS VSS.t3 126.334
R55 VSS.t2 VSS.t11 119.13
R56 VSS VSS.t4 115.079
R57 VSS VSS.t12 78.2103
R58 VSS.t2 VSS 1.15032
R59 a_4028_987.t0 a_4028_987.t1 1.16186
R60 a_2812_987.t1 a_2812_987.t0 1.907
R61 a_2044_987.t1 a_2044_987.t0 1.907
R62 a_828_987.t1 a_828_987.t0 1.16186
R63 out2.n0 out2.t4 5.80209
R64 out2.n1 out2.t6 5.28225
R65 out2.n0 out2.t5 5.13542
R66 out2.n1 out2.t7 2.64336
R67 out2.n0 out2.t2 1.74074
R68 out2.t0 out2.n0 1.59465
R69 out2.t0 out2.t3 1.37914
R70 out2.t0 out2.t1 1.13779
R71 out2.t1 out2.n1 1.04252
R72 in2.n0 in2.t4 5.19098
R73 in2.n0 in2.t5 2.64336
R74 in2.t2 in2.t0 1.81464
R75 in2.t2 in2.t1 1.25908
R76 in2.t0 in2.n0 1.04409
R77 in2.t1 in2.t3 1.07826
R78 CLKNb.n0 CLKNb.t4 5.5005
R79 CLKNb.n1 CLKNb.t6 4.90526
R80 CLKNb.n0 CLKNb.t2 3.50986
R81 CLKNb.n1 CLKNb.t7 2.81002
R82 CLKNb.n0 CLKNb.t5 2.64336
R83 CLKNb.n2 CLKNb.n1 2.17866
R84 CLKNb.n1 CLKNb.n0 2.02374
R85 CLKNb.n2 CLKNb.t3 1.37082
R86 CLKNb.t0 CLKNb.n2 1.2836
R87 CLKNb.t0 CLKNb.t1 1.12232
R88 in1.t2 in1.n2 0.0251473
R89 in1.n6 in1.n0 13.5005
R90 in1.n5 in1.n6 7.5005
R91 in1.n10 in1.t5 5.5005
R92 in1.n8 in1.n3 3.17838
R93 in1.t3 in1.n10 3.17136
R94 in1.n10 in1.t6 2.64336
R95 in1.n3 in1.n4 2.32058
R96 in1.t0 in1.t4 1.54301
R97 in1.n5 in1.n7 1.5005
R98 in1.t0 in1.n0 1.34441
R99 in1.t0 in1.t3 1.17558
R100 in1.n4 in1.n7 1.14324
R101 in1.n8 in1.n7 0.785598
R102 in1.n9 in1.n8 0.5005
R103 in1.n9 in1.n6 0.5005
R104 in1.t2 in1.n5 0.5005
R105 in1.n1 in1.t2 0.0156763
R106 in1.t2 in1.n4 0.322839
R107 in1.n2 in1.n0 0.616409
R108 in1.n9 in1.n1 0.251526
R109 in1.n0 in1.t1 1.04852
R110 in1.n3 in1.n2 1.04106
R111 in1.n0 in1.n1 1.02936
C0 CLK out1 0.32971f
C1 Q VDD 0.2889f
C2 Q QN 0.27986f
C3 VDD QN 0.60489f
C4 VDD CLKN 0.43735f
C5 VDD CLK 1.47129f
C6 VDD D 0.28469f
C7 VDD out1 0.7341f
C8 CLKN CLK 0.2677f
C9 a_2135_203r# out1 0.18322f
C10 CLK D 0.20695f
C11 QN VSS 1.58908f
C12 VDD VSS 16.09587f
C13 a_4107_203r# VSS 0.56942f
C14 a_945_203r# VSS 0.87388f
C15 out1 VSS 0.16539f
C16 in1.t0 VSS 1.15003f
C17 in1.t1 VSS 0.35165f
C18 in1.n0 VSS 0.42438f
C19 in1.t3 VSS 1.16957f
C20 in1.n10 VSS 0.10649f
C21 CLKNb.t0 VSS 0.81308f
C22 CLKNb.t1 VSS 0.28435f
C23 CLKNb.n0 VSS 0.62825f
C24 CLKNb.n1 VSS 0.54627f
C25 CLKNb.n2 VSS 0.72064f
C26 in2.t3 VSS 0.53512f
C27 in2.t1 VSS 1.07315f
C28 in2.t0 VSS 0.54181f
C29 in2.n0 VSS 0.14871f
C30 out2.t0 VSS 1.41618f
C31 out2.n0 VSS 0.58033f
C32 out2.t1 VSS 0.69483f
C33 out2.n1 VSS 0.11586f
C34 a_828_987.t0 VSS 0.34492f
C35 a_828_987.t1 VSS 1.29445f
C36 a_2044_987.t0 VSS 0.52f
C37 a_2044_987.t1 VSS 0.41423f
C38 a_2812_987.t0 VSS 0.99374f
C39 a_2812_987.t1 VSS 0.41569f
C40 a_4028_987.t1 VSS 0.35929f
C41 a_4028_987.t0 VSS 0.85487f
C42 VSS.t2 VSS 0.24485f
C43 VDD.t1 VSS 6.92754f
C44 Q.t1 VSS 0.14422f
C45 Q.n0 VSS 0.15858f
C46 Q.t0 VSS 0.16127f
C47 Q.n1 VSS 0.48666f
.ends
