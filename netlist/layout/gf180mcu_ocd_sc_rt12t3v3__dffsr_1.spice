* NGSPICE file created from gf180mcu_ocd_sc_rt12t3v3__dffsr_1.ext - technology: gf180mcuD

.subckt gf180mcu_ocd_sc_rt12t3v3__dffsr_1 D CLK SN RN Q QN VDD VSS
X0 R RN VDD VDD pfet_03v3 ad=0.3341p pd=1.805u as=0.3341p ps=1.805u w=1.285u l=0.28u
X1 in1 CLKb a_4039_203r# VSS nfet_03v3 ad=0.3087p pd=2.01u as=0.52065p ps=3.23u w=1.02u l=0.28u
X2 in1 CLKN a_2065_203r# VSS nfet_03v3 ad=0.3087p pd=2.01u as=0.52065p ps=3.23u w=1.02u l=0.28u
X3 a_4039_203r# out1 VSS VSS nfet_03v3 ad=0.3087p pd=2.01u as=2.74793p ps=14.86u w=1.02u l=0.28u
X4 QN out2 VSS VSS nfet_03v3 ad=0.3087p pd=2.01u as=2.74793p ps=14.86u w=1.02u l=0.28u
X5 VDD CLK CLKN VDD pfet_03v3 ad=0.3341p pd=1.805u as=0.3341p ps=1.805u w=1.285u l=0.28u
X6 a_3938_987# out1 VDD VDD pfet_03v3 ad=0.3341p pd=1.805u as=0.3341p ps=1.805u w=1.285u l=0.28u
X7 a_5474_987# R out2 VDD pfet_03v3 ad=0.5654p pd=3.45u as=0.3341p ps=1.805u w=1.285u l=0.28u
X8 VDD out2 a_6694_987# VDD pfet_03v3 ad=0.3341p pd=1.805u as=0.5654p ps=3.45u w=1.285u l=0.28u
X9 a_4706_987# out1 VDD VDD pfet_03v3 ad=0.3341p pd=1.805u as=0.3341p ps=1.805u w=1.285u l=0.28u
X10 a_2065_203r# D VSS VSS nfet_03v3 ad=0.3087p pd=2.01u as=2.9769p ps=16.1u w=1.02u l=0.28u
X11 out1 SNb a_2824_203r# VSS nfet_03v3 ad=0.3087p pd=2.01u as=0.52065p ps=3.23u w=1.02u l=0.28u
X12 VDD D a_1948_987# VDD pfet_03v3 ad=0.3341p pd=1.805u as=0.5654p ps=3.45u w=1.285u l=0.28u
X13 VDD SNb a_2717_987# VDD pfet_03v3 ad=0.3341p pd=1.805u as=0.5654p ps=3.45u w=1.285u l=0.28u
X14 a_1948_987# CLKb in1 VDD pfet_03v3 ad=0.5654p pd=3.45u as=0.3341p ps=1.805u w=1.285u l=0.28u
X15 a_2717_987# R out1 VDD pfet_03v3 ad=0.5654p pd=3.45u as=0.3341p ps=1.805u w=1.285u l=0.28u
X16 VDD SN a_921_203r# VDD pfet_03v3 ad=0.3341p pd=1.805u as=0.3341p ps=1.805u w=1.285u l=0.28u
X17 in2 CLKN a_4706_987# VDD pfet_03v3 ad=0.3341p pd=1.805u as=0.3341p ps=1.805u w=1.285u l=0.28u
X18 VDD out2 QN VDD pfet_03v3 ad=0.3341p pd=1.805u as=0.3341p ps=1.805u w=1.285u l=0.28u
X19 a_6795_203r# out2 VSS VSS nfet_03v3 ad=0.3087p pd=2.01u as=2.74793p ps=14.86u w=1.02u l=0.28u
X20 a_1948_987# D VDD VDD pfet_03v3 ad=0.3341p pd=1.805u as=0.3341p ps=1.805u w=1.285u l=0.28u
X21 SNb a_921_203r# VSS VSS nfet_03v3 ad=0.3087p pd=2.01u as=2.9769p ps=16.1u w=1.02u l=0.28u
X22 a_2824_203r# in1 VSS VSS nfet_03v3 ad=0.3087p pd=2.015u as=2.9769p ps=16.1u w=1.02u l=0.28u
X23 VDD in1 a_2717_987# VDD pfet_03v3 ad=0.3341p pd=1.805u as=0.5654p ps=3.45u w=1.285u l=0.28u
X24 VDD SNb a_5474_987# VDD pfet_03v3 ad=0.3341p pd=1.805u as=0.5654p ps=3.45u w=1.285u l=0.28u
X25 CLKN CLK VSS VSS nfet_03v3 ad=0.3087p pd=2.01u as=2.9769p ps=16.1u w=1.02u l=0.28u
X26 SNb a_921_203r# VDD VDD pfet_03v3 ad=0.3341p pd=1.805u as=0.3341p ps=1.805u w=1.285u l=0.28u
X27 VDD RN R VDD pfet_03v3 ad=0.5654p pd=3.45u as=0.3341p ps=1.805u w=1.285u l=0.28u
X28 a_4706_987# CLKN in2 VDD pfet_03v3 ad=0.5654p pd=3.45u as=0.3341p ps=1.805u w=1.285u l=0.28u
X29 VDD in2 a_5474_987# VDD pfet_03v3 ad=0.3341p pd=1.805u as=0.5654p ps=3.45u w=1.285u l=0.28u
X30 Q QN VDD VDD pfet_03v3 ad=0.3341p pd=1.805u as=0.3341p ps=1.805u w=1.285u l=0.28u
X31 a_5574_203r# in2 VSS VSS nfet_03v3 ad=0.3087p pd=2.015u as=2.9769p ps=16.1u w=1.02u l=0.28u
X32 CLKb CLKN VDD VDD pfet_03v3 ad=0.3341p pd=1.805u as=0.3341p ps=1.805u w=1.285u l=0.28u
X33 a_5474_987# SNb VDD VDD pfet_03v3 ad=0.3341p pd=1.805u as=0.3341p ps=1.805u w=1.285u l=0.28u
X34 a_2717_987# in1 VDD VDD pfet_03v3 ad=0.5654p pd=3.45u as=0.3341p ps=1.805u w=1.285u l=0.28u
X35 in1 CLKN a_3938_987# VDD pfet_03v3 ad=0.3341p pd=1.805u as=0.3341p ps=1.805u w=1.285u l=0.28u
X36 a_6694_987# out2 VDD VDD pfet_03v3 ad=0.3341p pd=1.805u as=0.3341p ps=1.805u w=1.285u l=0.28u
X37 out2 SNb a_5574_203r# VSS nfet_03v3 ad=0.3087p pd=2.01u as=0.52065p ps=3.23u w=1.02u l=0.28u
X38 a_2717_987# SNb VDD VDD pfet_03v3 ad=0.3341p pd=1.805u as=0.3341p ps=1.805u w=1.285u l=0.28u
X39 VDD QN Q VDD pfet_03v3 ad=0.5654p pd=3.45u as=0.3341p ps=1.805u w=1.285u l=0.28u
X40 a_921_203r# SN VSS VSS nfet_03v3 ad=0.3087p pd=2.01u as=2.9769p ps=16.1u w=1.02u l=0.28u
X41 Q QN VSS VSS nfet_03v3 ad=0.3087p pd=2.01u as=2.9769p ps=16.1u w=1.02u l=0.28u
X42 CLKN CLK VDD VDD pfet_03v3 ad=0.3341p pd=1.805u as=0.5654p ps=3.45u w=1.285u l=0.28u
X43 VDD CLKN CLKb VDD pfet_03v3 ad=0.5654p pd=3.45u as=0.3341p ps=1.805u w=1.285u l=0.28u
X44 VDD out1 a_4706_987# VDD pfet_03v3 ad=0.3341p pd=1.805u as=0.5654p ps=3.45u w=1.285u l=0.28u
X45 in2 CLKb a_6694_987# VDD pfet_03v3 ad=0.3341p pd=1.805u as=0.3341p ps=1.805u w=1.285u l=0.28u
X46 CLKb CLKN VSS VSS nfet_03v3 ad=0.3087p pd=2.01u as=2.9769p ps=16.1u w=1.02u l=0.28u
X47 out1 R VSS VSS nfet_03v3 ad=0.3087p pd=2.01u as=2.74793p ps=14.86u w=1.02u l=0.28u
X48 a_921_203r# SN VDD VDD pfet_03v3 ad=0.3341p pd=1.805u as=0.5654p ps=3.45u w=1.285u l=0.28u
X49 in1 CLKb a_1948_987# VDD pfet_03v3 ad=0.3341p pd=1.805u as=0.3341p ps=1.805u w=1.285u l=0.28u
X50 out1 R a_2717_987# VDD pfet_03v3 ad=0.3341p pd=1.805u as=0.3341p ps=1.805u w=1.285u l=0.28u
X51 in2 CLKb a_4807_203r# VSS nfet_03v3 ad=0.3087p pd=2.01u as=0.52065p ps=3.23u w=1.02u l=0.28u
X52 VDD a_921_203r# SNb VDD pfet_03v3 ad=0.3341p pd=1.805u as=0.3341p ps=1.805u w=1.285u l=0.28u
X53 a_4807_203r# out1 VSS VSS nfet_03v3 ad=0.3087p pd=2.01u as=2.74793p ps=14.86u w=1.02u l=0.28u
X54 a_5474_987# in2 VDD VDD pfet_03v3 ad=0.5654p pd=3.45u as=0.3341p ps=1.805u w=1.285u l=0.28u
X55 a_6694_987# CLKb in2 VDD pfet_03v3 ad=0.5654p pd=3.45u as=0.3341p ps=1.805u w=1.285u l=0.28u
X56 QN out2 VDD VDD pfet_03v3 ad=0.3341p pd=1.805u as=0.5654p ps=3.45u w=1.285u l=0.28u
X57 R RN VSS VSS nfet_03v3 ad=0.3087p pd=2.015u as=2.9769p ps=16.1u w=1.02u l=0.28u
X58 out2 R VSS VSS nfet_03v3 ad=0.3087p pd=2.01u as=2.74793p ps=14.86u w=1.02u l=0.28u
X59 in2 CLKN a_6795_203r# VSS nfet_03v3 ad=0.3087p pd=2.01u as=0.53235p ps=3.25u w=1.02u l=0.28u
X60 VDD out1 a_3938_987# VDD pfet_03v3 ad=0.3341p pd=1.805u as=0.5654p ps=3.45u w=1.285u l=0.28u
X61 a_3938_987# CLKN in1 VDD pfet_03v3 ad=0.5654p pd=3.45u as=0.3341p ps=1.805u w=1.285u l=0.28u
X62 out2 R a_5474_987# VDD pfet_03v3 ad=0.3341p pd=1.805u as=0.3341p ps=1.805u w=1.285u l=0.28u
.ends
