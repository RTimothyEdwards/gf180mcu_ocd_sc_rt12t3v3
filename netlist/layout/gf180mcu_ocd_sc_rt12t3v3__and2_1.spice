* NGSPICE file created from gf180mcu_ocd_sc_rt12t3v3__and2_1.ext - technology: gf180mcuD

.subckt gf180mcu_ocd_sc_rt12t3v3__and2_1 A B Y VDD VSS
X0 a_236_987# A a_193_203r# VSS nfet_03v3 ad=0.3087p pd=2.015u as=0.52065p ps=3.23u w=1.02u l=0.28u
X1 VDD B a_236_987# VDD pfet_03v3 ad=0.3341p pd=1.805u as=0.3341p ps=1.805u w=1.285u l=0.28u
X2 Y a_236_987# VDD VDD pfet_03v3 ad=0.3341p pd=1.805u as=0.3341p ps=1.805u w=1.285u l=0.28u
X3 VDD a_236_987# Y VDD pfet_03v3 ad=0.5654p pd=3.45u as=0.3341p ps=1.805u w=1.285u l=0.28u
X4 a_236_987# A VDD VDD pfet_03v3 ad=0.3341p pd=1.805u as=0.3341p ps=1.805u w=1.285u l=0.28u
X5 a_236_987# B VDD VDD pfet_03v3 ad=0.3341p pd=1.805u as=0.5654p ps=3.45u w=1.285u l=0.28u
X6 VDD A a_236_987# VDD pfet_03v3 ad=0.3341p pd=1.805u as=0.3341p ps=1.805u w=1.285u l=0.28u
X7 a_193_203r# B VSS VSS nfet_03v3 ad=0.3087p pd=2.01u as=3.40955p ps=18.84u w=1.02u l=0.28u
X8 Y a_236_987# VSS VSS nfet_03v3 ad=0.3087p pd=2.01u as=3.40955p ps=18.84u w=1.02u l=0.28u
.ends
