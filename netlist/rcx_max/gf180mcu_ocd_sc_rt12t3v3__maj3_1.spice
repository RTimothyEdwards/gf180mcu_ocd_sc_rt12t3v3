* NGSPICE file created from gf180mcu_ocd_sc_rt12t3v3__maj3_1.ext - technology: gf180mcuD

.subckt gf180mcu_ocd_sc_rt12t3v3__maj3_1 A B C Y VDD VSS
X0 a_884_987.t1 C.t3 a_208_231r.t2 VDD.t1 pfet_03v3 ad=0.5654p pd=3.45u as=0.3341p ps=1.805u w=1.285u l=0.28u
X1 a_208_231r.t3 C.t2 a_1652_987.t1 VDD.t2 pfet_03v3 ad=0.3341p pd=1.805u as=0.5654p ps=3.45u w=1.285u l=0.28u
X2 a_973_203r# A.t0 VSS.t7 VSS.t6 nfet_03v3 ad=0.3087p pd=2.01u as=4.32993p ps=24.5u w=1.02u l=0.28u
X3 a_92_987.t3 A.t3 a_208_231r.t6 VDD.t15 pfet_03v3 ad=0.3341p pd=1.805u as=0.3341p ps=1.805u w=1.285u l=0.28u
X4 a_1942_145# C a_208_231r# VSS nfet_03v3 ad=0.54405p pd=3.27u as=0.3087p ps=2.01u w=1.02u l=0.28u
X5 Y.t1 a_208_231r.t9 VDD.t21 VDD.t20 pfet_03v3 ad=0.3341p pd=1.805u as=0.5654p ps=3.45u w=1.285u l=0.28u
X6 a_208_231r.t0 C.t0 a_973_203r# VSS.t0 nfet_03v3 ad=0.3087p pd=2.01u as=0.52065p ps=3.23u w=1.02u l=0.28u
X7 VDD.t19 A.t2 a_1652_987.t2 VDD.t18 pfet_03v3 ad=0.3341p pd=1.805u as=0.3341p ps=1.805u w=1.285u l=0.28u
X8 VDD.t13 a_208_231r.t8 Y.t0 VDD.t12 pfet_03v3 ad=0.5654p pd=3.45u as=0.3341p ps=1.805u w=1.285u l=0.28u
X9 a_884_987.t3 B.t2 VDD.t9 VDD.t8 pfet_03v3 ad=0.3341p pd=1.805u as=0.3341p ps=1.805u w=1.285u l=0.28u
X10 a_1652_987.t0 C.t1 a_208_231r.t4 VDD.t3 pfet_03v3 ad=0.3341p pd=1.805u as=0.3341p ps=1.805u w=1.285u l=0.28u
X11 a_1942_145# B.t0 VSS.t4 VSS.t3 nfet_03v3 ad=0.3087p pd=2.015u as=3.24745p ps=18.375u w=1.02u l=0.28u
X12 VDD.t5 B.t5 a_92_987.t0 VDD.t4 pfet_03v3 ad=0.3341p pd=1.805u as=0.3341p ps=1.805u w=1.285u l=0.28u
X13 a_208_231r.t1 C.t4 a_884_987.t0 VDD.t0 pfet_03v3 ad=0.3341p pd=1.805u as=0.3341p ps=1.805u w=1.285u l=0.28u
X14 a_208_231r.t5 A.t4 a_92_987.t2 VDD.t14 pfet_03v3 ad=0.3341p pd=1.805u as=0.5654p ps=3.45u w=1.285u l=0.28u
X15 a_382_145# B.t1 VSS.t2 VSS.t1 nfet_03v3 ad=0.3087p pd=2.01u as=3.24745p ps=18.375u w=1.02u l=0.28u
X16 a_92_987.t1 B.t4 VDD.t7 VDD.t6 pfet_03v3 ad=0.5654p pd=3.45u as=0.3341p ps=1.805u w=1.285u l=0.28u
X17 a_1652_987.t3 A.t1 VDD.t17 VDD.t16 pfet_03v3 ad=0.5654p pd=3.45u as=0.3341p ps=1.805u w=1.285u l=0.28u
X18 a_382_145# A a_208_231r# VSS.t5 nfet_03v3 ad=0.52065p pd=3.23u as=0.3087p ps=2.01u w=1.02u l=0.28u
X19 Y.t2 a_208_231r.t7 VSS.t9 VSS.t8 nfet_03v3 ad=0.3087p pd=2.01u as=4.32993p ps=24.5u w=1.02u l=0.28u
X20 VDD.t11 B.t3 a_884_987.t2 VDD.t10 pfet_03v3 ad=0.3341p pd=1.805u as=0.5654p ps=3.45u w=1.285u l=0.28u
R0 Y.n7 Y.t2 120.001
R1 Y.n1 Y.n6 115.718
R2 Y.n9 Y.n8 67.4693
R3 Y.n8 Y.n7 34.8011
R4 Y.n7 Y.n6 20.0898
R5 Y Y.n0 15.4075
R6 Y.n0 Y.n1 5.1751
R7 Y.n4 Y.n1 2.89242
R8 Y Y.n5 7.87949
R9 Y.n4 Y.n3 1.97827
R10 Y.n8 Y.n2 7.5005
R11 Y.n9 Y.n6 4.52242
R12 Y.n3 Y.t2 1.09191
R13 Y.n3 Y.n2 1.96464
R14 Y.n5 Y.t1 3.03552
R15 Y.n5 Y.t0 3.03552
R16 Y.n0 Y.t2 14.0052
R17 Y.n0 Y.n2 4.18614
R18 Y.n4 Y.n9 1.72383
R19 C.n0 C.t1 75.5394
R20 C.n3 C.t4 69.1331
R21 C.n3 C.t3 59.3457
R22 C.n0 C.t2 52.4707
R23 C C.n2 31.182
R24 C.n2 C.n1 15.2053
R25 C.n2 C.t0 15.1105
R26 C C.n3 7.5005
R27 C C.n0 5.53061
R28 B.n0 B.t2 64.0184
R29 B.n1 B.t5 63.81
R30 B.n1 B.t4 48.81
R31 B.n0 B.t3 48.6017
R32 B.n3 B.n2 30.7155
R33 B.n2 B.n0 8.07615
R34 B.n2 B.n1 7.8058
R35 B.n3 B.t1 14.0203
R36 B B.t0 13.9379
R37 B B.n3 2.34968
R38 A.n4 A.n3 307.5
R39 A.n10 A.t3 93.7505
R40 A.n6 A.n5 74.5898
R41 A.n0 A.t2 64.8517
R42 A.n10 A.t4 55.7148
R43 A.n0 A.t1 47.7684
R44 A.n8 A.n7 35.9661
R45 A.n11 A.n9 20.9646
R46 A.n3 A.n2 20.7085
R47 A.n6 A.n2 12.0226
R48 A.n8 A.n0 10.8288
R49 A.n11 A.n10 9.58383
R50 A.n5 A.n3 8.78735
R51 A.n7 A.n1 6.13225
R52 A.n7 A.n6 6.0005
R53 A.t0 A.n4 4.92276
R54 A.n2 A.n1 3.9392
R55 A.n5 A.t0 2.28378
R56 A.n4 A.n1 1.64162
R57 A.n11 A.n8 1.29773
R58 A A.t1 0.0005
R59 VDD.n80 VDD.n79 979.433
R60 VDD.n82 VDD.n81 164.505
R61 VDD.n49 VDD.n48 164.505
R62 VDD.n53 VDD.n52 164.505
R63 VDD.n54 VDD.n45 164.505
R64 VDD.n58 VDD.n57 164.505
R65 VDD.n62 VDD.n40 164.505
R66 VDD.n64 VDD.n63 164.505
R67 VDD.n67 VDD.n37 164.505
R68 VDD.n69 VDD.n36 164.505
R69 VDD.n73 VDD.n72 164.505
R70 VDD.n74 VDD.n32 164.505
R71 VDD.n78 VDD.n28 164.505
R72 VDD.n45 VDD.t10 152.755
R73 VDD.n72 VDD.t16 152.755
R74 VDD.n82 VDD.t14 141.005
R75 VDD.n54 VDD.t6 141.005
R76 VDD.t12 VDD.n28 141.005
R77 VDD.n59 VDD.t0 129.254
R78 VDD.n63 VDD.t1 129.254
R79 VDD.n64 VDD.t2 129.254
R80 VDD.n68 VDD.t3 129.254
R81 VDD.t15 VDD.n47 117.504
R82 VDD.n47 VDD.t4 117.504
R83 VDD.t20 VDD.n73 117.504
R84 VDD.n59 VDD.t8 105.754
R85 VDD.t18 VDD.n68 105.754
R86 VDD.t8 VDD.n58 58.752
R87 VDD.n69 VDD.t18 58.752
R88 VDD.n49 VDD.t15 47.0017
R89 VDD.n52 VDD.t4 47.0017
R90 VDD.n74 VDD.t20 47.0017
R91 VDD.t0 VDD.n40 35.2514
R92 VDD.t1 VDD.n62 35.2514
R93 VDD.t2 VDD.n37 35.2514
R94 VDD.t3 VDD.n67 35.2514
R95 VDD.n48 VDD.t14 23.5011
R96 VDD.t6 VDD.n53 23.5011
R97 VDD.n32 VDD.t12 23.5011
R98 VDD.n2 VDD.n27 13.1265
R99 VDD.n84 VDD.n83 23.3338
R100 VDD.n6 VDD.n20 6.5635
R101 VDD.n50 VDD.n20 23.3338
R102 VDD.n8 VDD.n7 6.5635
R103 VDD.n51 VDD.n7 23.3338
R104 VDD.n18 VDD.n44 6.5635
R105 VDD.n55 VDD.n44 23.3338
R106 VDD.n10 VDD.n9 6.5635
R107 VDD.n56 VDD.n9 23.3338
R108 VDD.n17 VDD.n42 6.5635
R109 VDD.n60 VDD.n42 23.3338
R110 VDD.n60 VDD.n41 23.3338
R111 VDD.n61 VDD.n11 6.5635
R112 VDD.n61 VDD.n39 23.3338
R113 VDD.n65 VDD.n12 6.5635
R114 VDD.n65 VDD.n38 23.3338
R115 VDD.n66 VDD.n13 6.5635
R116 VDD.n66 VDD.n35 23.3338
R117 VDD.n70 VDD.n35 23.3338
R118 VDD.n70 VDD.n16 6.5635
R119 VDD.n71 VDD.n33 23.3338
R120 VDD.n14 VDD.n31 6.5635
R121 VDD.n75 VDD.n31 23.3338
R122 VDD.n75 VDD.n30 23.3338
R123 VDD.n15 VDD.n30 6.5635
R124 VDD.n77 VDD.n76 23.3338
R125 VDD.n25 VDD.n22 23.3338
R126 VDD.n24 VDD.n23 23.3338
R127 VDD.n5 VDD.n29 11.7458
R128 VDD.n4 VDD.n34 15.2628
R129 VDD.n3 VDD.n43 15.2628
R130 VDD.n3 VDD.n46 15.2628
R131 VDD VDD.n84 15.0005
R132 VDD.n83 VDD.n82 15.0005
R133 VDD.n83 VDD.n6 6.5635
R134 VDD.n48 VDD.n20 15.0005
R135 VDD VDD.n6 4.21975
R136 VDD.n50 VDD.n49 15.0005
R137 VDD.n8 VDD.n50 6.5635
R138 VDD.n47 VDD.n7 15.0005
R139 VDD VDD.n8 4.21975
R140 VDD.n52 VDD.n51 15.0005
R141 VDD.n51 VDD.n18 6.5635
R142 VDD.n53 VDD.n44 15.0005
R143 VDD.n18 VDD.n3 4.21975
R144 VDD.n55 VDD.n54 15.0005
R145 VDD.n10 VDD.n55 6.5635
R146 VDD.n45 VDD.n9 15.0005
R147 VDD.n3 VDD.n10 4.21975
R148 VDD.n57 VDD.n56 15.0005
R149 VDD.n56 VDD.n17 6.5635
R150 VDD.n58 VDD.n42 15.0005
R151 VDD.n17 VDD.n3 4.21975
R152 VDD.n60 VDD.n59 15.0005
R153 VDD.n3 VDD.n60 15.0005
R154 VDD.n41 VDD.n40 15.0005
R155 VDD.n11 VDD.n41 6.5635
R156 VDD.n62 VDD.n61 15.0005
R157 VDD.n11 VDD.n3 4.21975
R158 VDD.n63 VDD.n39 15.0005
R159 VDD.n39 VDD.n12 6.5635
R160 VDD.n65 VDD.n64 15.0005
R161 VDD.n3 VDD.n12 4.21975
R162 VDD.n38 VDD.n37 15.0005
R163 VDD.n13 VDD.n38 6.5635
R164 VDD.n67 VDD.n66 15.0005
R165 VDD.n13 VDD.n4 4.21975
R166 VDD.n68 VDD.n35 15.0005
R167 VDD.n35 VDD.n4 15.0005
R168 VDD.n70 VDD.n69 15.0005
R169 VDD.n4 VDD.n16 4.21975
R170 VDD.n36 VDD.n33 15.0005
R171 VDD.n16 VDD.n33 6.5635
R172 VDD.n72 VDD.n71 15.0005
R173 VDD.n71 VDD.n14 6.5635
R174 VDD.n73 VDD.n31 15.0005
R175 VDD.n14 VDD.n4 4.21975
R176 VDD.n75 VDD.n74 15.0005
R177 VDD.n4 VDD.n75 15.0005
R178 VDD.n32 VDD.n30 15.0005
R179 VDD.n4 VDD.n15 4.21975
R180 VDD.n76 VDD.n28 15.0005
R181 VDD.n76 VDD.n15 6.5635
R182 VDD.n78 VDD.n77 15.0005
R183 VDD.n77 VDD.n5 5.18282
R184 VDD.n79 VDD.n78 15.0005
R185 VDD.n2 VDD.n1 4.21975
R186 VDD.n5 VDD.n1 4.91009
R187 VDD.n23 VDD 15.0005
R188 VDD VDD.n24 15.0005
R189 VDD VDD.n25 15.0005
R190 VDD.n81 VDD.n22 15.0005
R191 VDD.n81 VDD.n80 15.0005
R192 VDD.n27 VDD.n0 13.0955
R193 VDD.n57 VDD.t10 11.7508
R194 VDD.n36 VDD.t16 11.7508
R195 VDD.n4 VDD.t13 10.895
R196 VDD.n4 VDD.t21 10.8927
R197 VDD.n80 VDD.n26 6.64275
R198 VDD.n79 VDD.n0 6.64275
R199 VDD.n2 VDD.n29 13.1265
R200 VDD.n25 VDD.n21 6.5635
R201 VDD.n24 VDD.n21 6.5635
R202 VDD.n26 VDD.n22 6.53249
R203 VDD.n23 VDD.n19 5.18282
R204 VDD.n84 VDD.n19 5.18282
R205 VDD.n81 VDD.n19 4.91009
R206 VDD.n1 VDD.n0 4.52391
R207 VDD.n26 VDD 4.52391
R208 VDD.n78 VDD.n27 4.21975
R209 VDD.n78 VDD.n29 4.21975
R210 VDD.n81 VDD.n21 4.21975
R211 VDD.n34 VDD.t19 3.03552
R212 VDD.n34 VDD.t17 3.03552
R213 VDD.n43 VDD.t11 3.03552
R214 VDD.n43 VDD.t9 3.03552
R215 VDD.n46 VDD.t5 3.03552
R216 VDD.n46 VDD.t7 3.03552
R217 VDD.n4 VDD.n1 1.4981
R218 VDD.n3 VDD 1.2069
R219 VDD.n4 VDD.n3 1.06823
R220 VSS.n80 VSS.n79 1006.93
R221 VSS.n82 VSS.n36 513.399
R222 VSS.n86 VSS.n85 513.399
R223 VSS.n87 VSS.n86 513.399
R224 VSS.n87 VSS.n34 513.399
R225 VSS.n51 VSS.n48 513.399
R226 VSS.n52 VSS.n51 513.399
R227 VSS.n53 VSS.n46 513.399
R228 VSS.n56 VSS.n46 513.399
R229 VSS.n57 VSS.n56 513.399
R230 VSS.n58 VSS.n44 513.399
R231 VSS.n61 VSS.n44 513.399
R232 VSS.n64 VSS.n63 513.399
R233 VSS.n64 VSS.n41 513.399
R234 VSS.n67 VSS.n41 513.399
R235 VSS.n69 VSS.n68 513.399
R236 VSS.n69 VSS.n40 513.399
R237 VSS.n73 VSS.n72 513.399
R238 VSS.n74 VSS.n73 513.399
R239 VSS.n74 VSS.n37 513.399
R240 VSS.n58 VSS.t0 485.897
R241 VSS.n68 VSS.t3 435.474
R242 VSS.n48 VSS.t1 417.137
R243 VSS.n36 VSS.t5 316.291
R244 VSS.t6 VSS.n52 297.955
R245 VSS.n62 VSS.n61 279.62
R246 VSS.n40 VSS.t8 261.284
R247 VSS.n72 VSS.t8 252.117
R248 VSS.n63 VSS.n62 233.78
R249 VSS.n53 VSS.t6 215.445
R250 VSS.n85 VSS.t5 197.109
R251 VSS.t1 VSS.n34 96.2628
R252 VSS.t3 VSS.n67 77.9272
R253 VSS.t0 VSS.n57 27.504
R254 VSS.n75 VSS.n24 6.5635
R255 VSS.n70 VSS.n30 23.3338
R256 VSS.n18 VSS.n45 6.5635
R257 VSS.n59 VSS.n45 23.3338
R258 VSS.n20 VSS.n19 6.5635
R259 VSS.n60 VSS.n19 23.3338
R260 VSS.n21 VSS.n43 6.5635
R261 VSS.n65 VSS.n43 23.3338
R262 VSS.n23 VSS.n22 6.5635
R263 VSS.n50 VSS.n29 23.3338
R264 VSS.n83 VSS.n16 23.3338
R265 VSS.n84 VSS.n16 23.3338
R266 VSS.n17 VSS.n33 6.5635
R267 VSS.n88 VSS.n33 23.3338
R268 VSS.n75 VSS.n32 22.6988
R269 VSS.n26 VSS.n10 6.46182
R270 VSS.n66 VSS.n22 22.5884
R271 VSS.n55 VSS.n31 22.4779
R272 VSS.n54 VSS.n25 6.14636
R273 VSS.n28 VSS.n6 6.12707
R274 VSS.n27 VSS.n30 6.1077
R275 VSS.n50 VSS.n15 6.1077
R276 VSS.n5 VSS.n32 6.45409
R277 VSS.n11 VSS.n10 16.9885
R278 VSS.n66 VSS.n8 6.29471
R279 VSS.n83 VSS.n35 15.8338
R280 VSS.n76 VSS.n38 15.8338
R281 VSS.n3 VSS.n31 6.12927
R282 VSS.n1 VSS.n80 15.2537
R283 VSS.n79 VSS.n0 15.2537
R284 VSS.n88 VSS.n87 15.0005
R285 VSS.n26 VSS.n88 6.46182
R286 VSS.n86 VSS.n33 15.0005
R287 VSS.n17 VSS 4.21975
R288 VSS.n85 VSS.n84 15.0005
R289 VSS.n84 VSS.n17 6.5635
R290 VSS.n36 VSS.n16 15.0005
R291 VSS VSS.n16 15.0005
R292 VSS.n83 VSS.n82 15.0005
R293 VSS VSS.n83 15.0005
R294 VSS.n9 VSS.n48 15.0005
R295 VSS.n15 VSS.n9 6.1077
R296 VSS.n34 VSS.n10 15.0005
R297 VSS.n26 VSS 4.27059
R298 VSS.n52 VSS.n29 15.0005
R299 VSS.n25 VSS.n29 6.14636
R300 VSS.n51 VSS.n50 15.0005
R301 VSS.n15 VSS 4.44765
R302 VSS.n31 VSS.n46 15.0005
R303 VSS VSS.n3 2.95824
R304 VSS.n54 VSS.n53 15.0005
R305 VSS.n25 VSS 4.42832
R306 VSS.n22 VSS.n41 15.0005
R307 VSS.n0 VSS.n23 4.21975
R308 VSS.n65 VSS.n64 15.0005
R309 VSS.n23 VSS.n65 6.5635
R310 VSS.n63 VSS.n43 15.0005
R311 VSS.n21 VSS.n0 4.21975
R312 VSS.n61 VSS.n60 15.0005
R313 VSS.n60 VSS.n21 6.5635
R314 VSS.n19 VSS.n44 15.0005
R315 VSS.n0 VSS.n20 4.21975
R316 VSS.n59 VSS.n58 15.0005
R317 VSS.n20 VSS.n59 6.5635
R318 VSS.n57 VSS.n45 15.0005
R319 VSS.n18 VSS.n0 4.21975
R320 VSS.n56 VSS.n55 15.0005
R321 VSS.n55 VSS.n18 6.5635
R322 VSS.n68 VSS.n6 15.0005
R323 VSS.n0 VSS.n28 4.43796
R324 VSS.n67 VSS.n66 15.0005
R325 VSS.n8 VSS.n0 2.9031
R326 VSS.n40 VSS.n30 15.0005
R327 VSS.n0 VSS.n27 4.44765
R328 VSS.n70 VSS.n69 15.0005
R329 VSS.n28 VSS.n70 6.12707
R330 VSS.n73 VSS.n32 15.0005
R331 VSS.n0 VSS.n5 2.84997
R332 VSS.n72 VSS.n71 15.0005
R333 VSS.n71 VSS.n27 6.1077
R334 VSS.n38 VSS.n37 15.0005
R335 VSS.n24 VSS.n38 6.5635
R336 VSS.n75 VSS.n74 15.0005
R337 VSS.n0 VSS.n24 4.21975
R338 VSS.n14 VSS.n0 4.21975
R339 VSS.n77 VSS.n14 13.1265
R340 VSS.n76 VSS.n0 15.0005
R341 VSS.n35 VSS.n1 15.0005
R342 VSS.n1 VSS.n13 4.21975
R343 VSS.n4 VSS.t9 10.9505
R344 VSS.n7 VSS.t4 10.9505
R345 VSS.n11 VSS.t2 10.9505
R346 VSS.n2 VSS.t7 10.5005
R347 VSS VSS.n11 7.5005
R348 VSS.n3 VSS.n2 3.06513
R349 VSS.n8 VSS.n7 3.14785
R350 VSS.n5 VSS.n4 3.22754
R351 VSS.n2 VSS.n47 6.6005
R352 VSS.n80 VSS.n12 6.5635
R353 VSS.n79 VSS.n78 6.5635
R354 VSS.n81 VSS.n35 6.5635
R355 VSS.n81 VSS.n13 13.1265
R356 VSS.n13 VSS.n12 13.1265
R357 VSS.n77 VSS.n76 6.5635
R358 VSS.n78 VSS.n14 13.1265
R359 VSS.n4 VSS.n39 6.3005
R360 VSS.n7 VSS.n42 6.3005
R361 VSS.n11 VSS.n49 6.3005
R362 VSS.n2 VSS.n54 5.1493
R363 VSS.n7 VSS.n6 4.2764
R364 VSS.n78 VSS.n37 4.21975
R365 VSS.n77 VSS.n37 4.21975
R366 VSS.n82 VSS.n81 4.21975
R367 VSS.n82 VSS.n12 4.21975
R368 VSS.n11 VSS.n9 3.55351
R369 VSS.n71 VSS.n4 3.55351
R370 VSS.n0 VSS 2.34743
R371 VSS.n0 VSS 2.19058
R372 VSS.n0 VSS 2.02157
R373 VSS.n0 VSS 1.4612
R374 VSS.n0 VSS 1.33258
R375 VSS VSS.n1 1.24201
R376 a_1652_987.n0 a_1652_987.t3 11.571
R377 a_1652_987.n0 a_1652_987.t1 11.5552
R378 a_1652_987.n1 a_1652_987.n0 7.5005
R379 a_1652_987.t2 a_1652_987.n1 3.03552
R380 a_1652_987.n1 a_1652_987.t0 3.03552
R381 a_884_987.t2 a_884_987.n1 11.571
R382 a_884_987.n1 a_884_987.t1 11.5552
R383 a_884_987.n1 a_884_987.n0 7.5005
R384 a_884_987.n0 a_884_987.t0 3.03552
R385 a_884_987.n0 a_884_987.t3 3.03552
R386 a_92_987.t1 a_92_987.n1 11.571
R387 a_92_987.n1 a_92_987.t2 11.5552
R388 a_92_987.n1 a_92_987.n0 7.5005
R389 a_92_987.n0 a_92_987.t0 3.03552
R390 a_92_987.n0 a_92_987.t3 3.03552
R391 a_208_231r.n26 a_208_231r.n25 307.5
R392 a_208_231r.t0 a_208_231r.n7 4.01391
R393 a_208_231r.t0 a_208_231r.n0 0.361235
R394 a_208_231r.n1 a_208_231r.n6 4.01391
R395 a_208_231r.n13 a_208_231r.n12 202.5
R396 a_208_231r.n37 a_208_231r.n32 202.5
R397 a_208_231r.n42 a_208_231r.n10 202.5
R398 a_208_231r.n11 a_208_231r.n13 112.501
R399 a_208_231r.n3 a_208_231r.n32 116.52
R400 a_208_231r.n42 a_208_231r.n41 112.501
R401 a_208_231r.n2 a_208_231r.n1 3.41354
R402 a_208_231r.n22 a_208_231r.t9 80.1265
R403 a_208_231r.n22 a_208_231r.t8 79.7155
R404 a_208_231r.n28 a_208_231r.n27 74.3292
R405 a_208_231r.n19 a_208_231r.n15 47.6272
R406 a_208_231r.n36 a_208_231r.n33 37.861
R407 a_208_231r.n17 a_208_231r.n16 34.8478
R408 a_208_231r.n46 a_208_231r.n21 30.9234
R409 a_208_231r.n45 a_208_231r.n9 30.9085
R410 a_208_231r.n39 a_208_231r.n31 30.7388
R411 a_208_231r.n45 a_208_231r.n40 30.7243
R412 a_208_231r.n47 a_208_231r.n46 30.7181
R413 a_208_231r.n1 a_208_231r.n34 30.2684
R414 a_208_231r.n18 a_208_231r.n11 21.9978
R415 a_208_231r.n25 a_208_231r.n24 20.7085
R416 a_208_231r.n19 a_208_231r.n18 18.2526
R417 a_208_231r.n18 a_208_231r.n17 17.8056
R418 a_208_231r.n4 a_208_231r.n45 17.2646
R419 a_208_231r.n46 a_208_231r.n4 15.0005
R420 a_208_231r.n4 a_208_231r.n39 15.0005
R421 a_208_231r.n9 a_208_231r.n10 15.0005
R422 a_208_231r.n44 a_208_231r.n41 12.4575
R423 a_208_231r.n28 a_208_231r.n24 12.0226
R424 a_208_231r.n35 a_208_231r.n34 11.2505
R425 a_208_231r.n27 a_208_231r.n25 8.78735
R426 a_208_231r.n30 a_208_231r.n29 8.07802
R427 a_208_231r.n30 a_208_231r.n22 7.89868
R428 a_208_231r.n20 a_208_231r.n19 7.60067
R429 a_208_231r.n16 a_208_231r.n0 11.6304
R430 a_208_231r.n20 a_208_231r.n13 7.5005
R431 a_208_231r.t0 a_208_231r.n11 7.5005
R432 a_208_231r.n3 a_208_231r.n35 7.57091
R433 a_208_231r.n38 a_208_231r.n37 7.5005
R434 a_208_231r.n38 a_208_231r.n33 7.5005
R435 a_208_231r.n35 a_208_231r.n33 30.7907
R436 a_208_231r.n10 a_208_231r.n5 20.2114
R437 a_208_231r.n29 a_208_231r.n23 7.41523
R438 a_208_231r.n21 a_208_231r.t0 6.98326
R439 a_208_231r.n39 a_208_231r.n2 32.2074
R440 a_208_231r.n37 a_208_231r.n36 6.85139
R441 a_208_231r.n8 a_208_231r.n41 4.48407
R442 a_208_231r.n10 a_208_231r.n44 4.98282
R443 a_208_231r.t7 a_208_231r.n26 4.9219
R444 a_208_231r.n17 a_208_231r.t0 4.65696
R445 a_208_231r.n29 a_208_231r.n28 4.60446
R446 a_208_231r.n0 a_208_231r.n12 9.20397
R447 a_208_231r.n20 a_208_231r.n7 0.0778758
R448 a_208_231r.n12 a_208_231r.n7 116.513
R449 a_208_231r.n3 a_208_231r.n1 3.65029
R450 a_208_231r.n38 a_208_231r.n6 0.0778758
R451 a_208_231r.n32 a_208_231r.n6 116.513
R452 a_208_231r.n5 a_208_231r.n8 7.22871
R453 a_208_231r.n36 a_208_231r.n1 4.50901
R454 a_208_231r.n43 a_208_231r.n42 4.16717
R455 a_208_231r.n9 a_208_231r.n43 4.16717
R456 a_208_231r.n16 a_208_231r.n15 3.95439
R457 a_208_231r.n24 a_208_231r.n23 3.94768
R458 a_208_231r.n21 a_208_231r.n12 3.87981
R459 a_208_231r.n2 a_208_231r.n32 1.89685
R460 a_208_231r.n47 a_208_231r.t1 3.03552
R461 a_208_231r.t2 a_208_231r.n47 3.03552
R462 a_208_231r.n31 a_208_231r.t3 3.03552
R463 a_208_231r.n31 a_208_231r.t4 3.03552
R464 a_208_231r.n40 a_208_231r.t5 3.03552
R465 a_208_231r.n40 a_208_231r.t6 3.03552
R466 a_208_231r.n4 a_208_231r.n30 2.29668
R467 a_208_231r.n9 a_208_231r.n8 0.192943
R468 a_208_231r.n27 a_208_231r.t7 2.28378
R469 a_208_231r.n26 a_208_231r.n23 1.62891
R470 a_208_231r.n44 a_208_231r.n43 1.501
R471 a_208_231r.n15 a_208_231r.n14 1.40041
C0 A VDD 1.17856f
C1 A a_973_203r# 0.10344f
C2 a_382_145# B 0.10344f
C3 Y VDD 0.31119f
C4 C B 0.32166f
C5 C VDD 0.73746f
C6 C A 0.36794f
C7 VDD B 0.74884f
C8 A B 0.57616f
C9 a_1942_145# B 0.11461f
C10 Y VSS 0.57675f
C11 B VSS 1.8002f
C12 VDD VSS 8.41898f
C13 a_1942_145# VSS 0.93491f
C14 a_973_203r# VSS 0.23239f
C15 a_382_145# VSS 0.84027f
C16 a_208_231r.t0 VSS 0.1941f
C17 a_208_231r.n4 VSS 0.71581f
C18 a_208_231r.n22 VSS 0.15424f
C19 a_208_231r.n27 VSS 0.15134f
C20 a_208_231r.n28 VSS 0.26032f
C21 a_208_231r.n30 VSS 0.35824f
C22 a_208_231r.n31 VSS 0.13847f
C23 a_208_231r.n39 VSS 0.43285f
C24 a_208_231r.t6 VSS 0.12022f
C25 a_208_231r.t5 VSS 0.10288f
C26 a_208_231r.n40 VSS 0.14605f
C27 a_208_231r.n45 VSS 0.4711f
C28 a_208_231r.n46 VSS 0.43919f
C29 a_208_231r.n47 VSS 0.14524f
C30 a_92_987.t2 VSS 0.21059f
C31 a_92_987.t0 VSS 0.10565f
C32 a_92_987.t3 VSS 0.12877f
C33 a_92_987.n0 VSS 0.10027f
C34 a_92_987.n1 VSS 0.46397f
C35 a_92_987.t1 VSS 0.19916f
C36 a_884_987.t1 VSS 0.19778f
C37 a_884_987.t0 VSS 0.10127f
C38 a_884_987.t3 VSS 0.10601f
C39 a_884_987.n0 VSS 0.10077f
C40 a_884_987.n1 VSS 0.46628f
C41 a_884_987.t2 VSS 0.19977f
C42 a_1652_987.t0 VSS 0.10506f
C43 a_1652_987.t1 VSS 0.19598f
C44 a_1652_987.t3 VSS 0.21154f
C45 a_1652_987.n0 VSS 0.46459f
C46 a_1652_987.n1 VSS 0.10041f
C47 a_1652_987.t2 VSS 0.12102f
C48 VSS.t4 VSS 0.20279f
C49 VSS.t2 VSS 0.20188f
C50 VDD.n3 VSS 0.23854f
C51 VDD.n4 VSS 0.25547f
C52 VDD.n28 VSS 0.12343f
C53 VDD.n45 VSS 0.12818f
C54 VDD.n54 VSS 0.12343f
C55 VDD.n63 VSS 0.11869f
C56 VDD.n64 VSS 0.11869f
C57 VDD.n72 VSS 0.12818f
C58 VDD.n73 VSS 0.11394f
C59 VDD.n78 VSS 0.19939f
C60 VDD.n79 VSS 0.10185f
C61 VDD.n80 VSS 0.10185f
C62 VDD.n81 VSS 0.22313f
C63 VDD.n82 VSS 0.12343f
C64 A.n0 VSS 0.27129f
C65 A.n5 VSS 0.19266f
C66 A.n6 VSS 0.32831f
C67 A.n7 VSS 0.22877f
C68 A.n8 VSS 0.80779f
C69 A.n9 VSS 0.49836f
C70 A.n10 VSS 0.19687f
C71 A.n11 VSS 0.72143f
C72 B.n0 VSS 0.13577f
C73 B.n1 VSS 0.13271f
C74 B.n2 VSS 0.26184f
C75 B.n3 VSS 0.57574f
C76 C.n0 VSS 0.16476f
C77 C.n1 VSS 0.40194f
C78 C.n2 VSS 0.61325f
C79 C.n3 VSS 0.11298f
.ends
