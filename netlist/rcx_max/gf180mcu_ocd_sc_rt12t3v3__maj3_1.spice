* NGSPICE file created from gf180mcu_ocd_sc_rt12t3v3__maj3_1.ext - technology: gf180mcuD

.subckt gf180mcu_ocd_sc_rt12t3v3__maj3_1 A B C Y VDD VSS
X0 a_884_987# C a_208_231r# VDD pfet_03v3 ad=0.5654p pd=3.45u as=0.3341p ps=1.805u w=1.285u l=0.28u
X1 a_208_231r# C a_1652_987# VDD pfet_03v3 ad=0.3341p pd=1.805u as=0.5654p ps=3.45u w=1.285u l=0.28u
X2 a_973_203r# A VSS VSS nfet_03v3 ad=0.3087p pd=2.01u as=4.32993p ps=24.5u w=1.02u l=0.28u
X3 a_92_987# A a_208_231r# VDD pfet_03v3 ad=0.3341p pd=1.805u as=0.3341p ps=1.805u w=1.285u l=0.28u
X4 a_1942_145# C a_208_231r# VSS nfet_03v3 ad=0.54405p pd=3.27u as=0.3087p ps=2.01u w=1.02u l=0.28u
X5 Y a_208_231r# VDD VDD pfet_03v3 ad=0.3341p pd=1.805u as=0.5654p ps=3.45u w=1.285u l=0.28u
X6 a_208_231r# C a_973_203r# VSS nfet_03v3 ad=0.3087p pd=2.01u as=0.52065p ps=3.23u w=1.02u l=0.28u
X7 VDD A a_1652_987# VDD pfet_03v3 ad=0.3341p pd=1.805u as=0.3341p ps=1.805u w=1.285u l=0.28u
X8 VDD a_208_231r# Y VDD pfet_03v3 ad=0.5654p pd=3.45u as=0.3341p ps=1.805u w=1.285u l=0.28u
X9 a_884_987# B VDD VDD pfet_03v3 ad=0.3341p pd=1.805u as=0.3341p ps=1.805u w=1.285u l=0.28u
X10 a_1652_987# C a_208_231r# VDD pfet_03v3 ad=0.3341p pd=1.805u as=0.3341p ps=1.805u w=1.285u l=0.28u
X11 a_1942_145# B VSS VSS nfet_03v3 ad=0.3087p pd=2.015u as=3.24745p ps=18.375u w=1.02u l=0.28u
X12 VDD B a_92_987# VDD pfet_03v3 ad=0.3341p pd=1.805u as=0.3341p ps=1.805u w=1.285u l=0.28u
X13 a_208_231r# C a_884_987# VDD pfet_03v3 ad=0.3341p pd=1.805u as=0.3341p ps=1.805u w=1.285u l=0.28u
X14 a_208_231r# A a_92_987# VDD pfet_03v3 ad=0.3341p pd=1.805u as=0.5654p ps=3.45u w=1.285u l=0.28u
X15 a_382_145# B VSS VSS nfet_03v3 ad=0.3087p pd=2.01u as=3.24745p ps=18.375u w=1.02u l=0.28u
X16 a_92_987# B VDD VDD pfet_03v3 ad=0.5654p pd=3.45u as=0.3341p ps=1.805u w=1.285u l=0.28u
X17 a_1652_987# A VDD VDD pfet_03v3 ad=0.5654p pd=3.45u as=0.3341p ps=1.805u w=1.285u l=0.28u
X18 a_382_145# A a_208_231r# VSS nfet_03v3 ad=0.52065p pd=3.23u as=0.3087p ps=2.01u w=1.02u l=0.28u
X19 Y a_208_231r# VSS VSS nfet_03v3 ad=0.3087p pd=2.01u as=4.32993p ps=24.5u w=1.02u l=0.28u
X20 VDD B a_884_987# VDD pfet_03v3 ad=0.3341p pd=1.805u as=0.5654p ps=3.45u w=1.285u l=0.28u
C0 a_208_231r# A 1.47918f
C1 B C 0.32166f
C2 a_208_231r# a_884_987# 0.20791f
C3 a_208_231r# VDD 0.84861f
C4 VDD a_92_987# 0.48191f
C5 a_208_231r# B 0.78491f
C6 A VDD 1.17856f
C7 VDD a_884_987# 0.42313f
C8 a_92_987# B 0.16997f
C9 A B 0.57616f
C10 B a_884_987# 0.16023f
C11 VDD B 0.74884f
C12 a_1652_987# a_208_231r# 0.2015f
C13 a_208_231r# Y 0.47077f
C14 a_208_231r# a_1942_145# 0.12665f
C15 a_1652_987# A 0.14431f
C16 a_1652_987# VDD 0.47118f
C17 a_973_203r# A 0.10344f
C18 a_382_145# B 0.10344f
C19 VDD Y 0.31119f
C20 a_208_231r# C 0.79407f
C21 a_1942_145# B 0.11461f
C22 A C 0.36794f
C23 VDD C 0.73746f
C24 a_208_231r# a_92_987# 0.19666f
C25 Y VSS 0.96497f
C26 VDD VSS 9.61478f
C27 a_973_203r# VSS 0.63338f
C28 a_884_987# VSS 1.0459f
.ends
