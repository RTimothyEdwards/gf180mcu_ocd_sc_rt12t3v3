* NGSPICE file created from gf180mcu_ocd_sc_rt12t3v3__tbuf_1.ext - technology: gf180mcuD

.subckt gf180mcu_ocd_sc_rt12t3v3__tbuf_1 A EN Y VDD VSS
X0 EN_BAR.t0 EN.t3 VDD.t1 VDD.t0 pfet_03v3 ad=0.3341p pd=1.805u as=0.5654p ps=3.45u w=1.285u l=0.28u
X1 a_211_203r# A.t0 VSS.t4 VSS.t3 nfet_03v3 ad=0.3087p pd=2.01u as=3.0308p ps=16.66u w=1.02u l=0.28u
X2 VDD.t7 A.t1 a_211_203r# VDD.t6 pfet_03v3 ad=0.5654p pd=3.45u as=0.3341p ps=1.805u w=1.285u l=0.28u
X3 VDD.t11 a_211_203r# a_540_987.t2 VDD.t10 pfet_03v3 ad=0.3341p pd=1.805u as=0.5654p ps=3.45u w=1.285u l=0.28u
X4 Y.t0 EN.t1 a_629_203r# VSS.t0 nfet_03v3 ad=0.3087p pd=2.01u as=0.52065p ps=3.23u w=1.02u l=0.28u
X5 a_540_987.t0 EN_BAR.t3 Y.t1 VDD.t8 pfet_03v3 ad=0.5654p pd=3.45u as=0.3341p ps=1.805u w=1.285u l=0.28u
X6 a_540_987.t3 a_211_203r# VDD.t13 VDD.t12 pfet_03v3 ad=0.3341p pd=1.805u as=0.3341p ps=1.805u w=1.285u l=0.28u
X7 VDD.t3 EN.t2 EN_BAR.t1 VDD.t2 pfet_03v3 ad=0.5654p pd=3.45u as=0.3341p ps=1.805u w=1.285u l=0.28u
X8 a_211_203r# A.t2 VDD.t5 VDD.t4 pfet_03v3 ad=0.3341p pd=1.805u as=0.5654p ps=3.45u w=1.285u l=0.28u
X9 Y.t2 EN_BAR.t4 a_540_987.t1 VDD.t9 pfet_03v3 ad=0.3341p pd=1.805u as=0.3341p ps=1.805u w=1.285u l=0.28u
X10 EN_BAR.t2 EN.t0 VSS.t2 VSS.t1 nfet_03v3 ad=0.3087p pd=2.01u as=3.0308p ps=16.66u w=1.02u l=0.28u
X11 a_629_203r# a_211_203r# VSS.t6 VSS.t5 nfet_03v3 ad=0.3087p pd=2.01u as=3.0308p ps=16.66u w=1.02u l=0.28u
R0 Y.n9 Y.n5 210
R1 Y.n12 Y.n2 202.5
R2 Y.n5 Y.n2 112.501
R3 Y.n13 Y.n12 112.501
R4 Y.n6 Y.n4 35.0626
R5 Y.n9 Y.n8 31.9491
R6 Y.n10 Y.n9 22.7684
R7 Y.n13 Y.n11 22.5005
R8 Y.n11 Y.n4 17.1346
R9 Y Y.n1 15.2775
R10 Y.n14 Y.t0 15.2591
R11 Y Y.n14 15.0977
R12 Y.n11 Y.n10 11.777
R13 Y.n6 Y.n0 10.8735
R14 Y.n10 Y.n3 7.5005
R15 Y.n12 Y.n3 7.5005
R16 Y.t0 Y.n13 7.5005
R17 Y.t0 Y.n0 0.489634
R18 Y.t0 Y.n4 4.82859
R19 Y.t0 Y.n3 4.42579
R20 Y.n5 Y.n3 4.16717
R21 Y.n14 Y.n2 3.87981
R22 Y.n0 Y.n2 9.25828
R23 Y.n1 Y.t2 3.03552
R24 Y.n1 Y.t1 3.03552
R25 Y.n8 Y.n7 2.72827
R26 Y.n8 Y.n6 2.38736
R27 EN.n4 EN.n3 307.5
R28 EN.n0 EN.t3 81.5648
R29 EN.n0 EN.t2 78.2772
R30 EN.n6 EN.n5 74.3292
R31 EN.n3 EN.n2 20.7085
R32 EN.n6 EN.n2 12.0226
R33 EN.n5 EN.n3 8.78735
R34 EN EN.n0 7.89007
R35 EN.n7 EN.n1 6.52414
R36 EN.n7 EN.n6 5.49555
R37 EN.t0 EN.n4 4.9219
R38 EN.n2 EN.n1 3.94768
R39 EN EN.t1 23.015
R40 EN EN.n7 8.04598
R41 EN.n5 EN.t0 2.28378
R42 EN.n4 EN.n1 1.62891
R43 A.n4 A.n3 99.5102
R44 A.n0 A.t1 82.5303
R45 A.n0 A.t2 72.9469
R46 A.n5 A.n4 64.5392
R47 A.n2 A.n1 29.0394
R48 A.n4 A.n2 10.9429
R49 A A.n0 8.28743
R50 A.n5 A.n1 6.49831
R51 A A.n5 6.18231
R52 A.n3 A.n1 4.44684
R53 A.n3 A.t0 4.19435
R54 A.t0 A.n2 2.84084
R55 VDD.n52 VDD.n51 597.615
R56 VDD.n54 VDD.n53 164.505
R57 VDD.n34 VDD.n32 164.505
R58 VDD.n36 VDD.n35 164.505
R59 VDD.n39 VDD.n28 164.505
R60 VDD.n41 VDD.n27 164.505
R61 VDD.n45 VDD.n44 164.505
R62 VDD.n46 VDD.n25 164.505
R63 VDD.n50 VDD.n21 164.505
R64 VDD.n54 VDD.t4 141.005
R65 VDD.n36 VDD.t10 141.005
R66 VDD.n44 VDD.t8 141.005
R67 VDD.t2 VDD.n21 141.005
R68 VDD.n35 VDD.t6 117.504
R69 VDD.n40 VDD.t12 117.504
R70 VDD.t9 VDD.n40 117.504
R71 VDD.t0 VDD.n45 117.504
R72 VDD.t6 VDD.n34 47.0017
R73 VDD.t12 VDD.n39 47.0017
R74 VDD.n41 VDD.t9 47.0017
R75 VDD.n46 VDD.t0 47.0017
R76 VDD.n32 VDD.t4 23.5011
R77 VDD.t10 VDD.n28 23.5011
R78 VDD.n27 VDD.t8 23.5011
R79 VDD.n25 VDD.t2 23.5011
R80 VDD.n2 VDD.n20 13.1265
R81 VDD.n56 VDD.n55 23.3338
R82 VDD.n55 VDD.n10 6.5635
R83 VDD.n33 VDD.n13 23.3338
R84 VDD.n5 VDD.n31 6.5635
R85 VDD.n37 VDD.n31 23.3338
R86 VDD.n37 VDD.n29 23.3338
R87 VDD.n11 VDD.n29 6.5635
R88 VDD.n38 VDD.n26 23.3338
R89 VDD.n42 VDD.n26 23.3338
R90 VDD.n7 VDD.n6 6.5635
R91 VDD.n43 VDD.n6 23.3338
R92 VDD.n8 VDD.n24 6.5635
R93 VDD.n47 VDD.n24 23.3338
R94 VDD.n47 VDD.n23 23.3338
R95 VDD.n9 VDD.n23 6.5635
R96 VDD.n49 VDD.n48 23.3338
R97 VDD.n18 VDD.n15 23.3338
R98 VDD.n17 VDD.n16 23.3338
R99 VDD.n4 VDD.n22 11.7458
R100 VDD VDD.n30 15.2628
R101 VDD VDD.n56 15.0005
R102 VDD.n55 VDD.n54 15.0005
R103 VDD.n10 VDD 4.21975
R104 VDD.n32 VDD.n13 15.0005
R105 VDD.n10 VDD.n13 6.5635
R106 VDD.n34 VDD.n33 15.0005
R107 VDD.n33 VDD.n5 6.5635
R108 VDD.n35 VDD.n31 15.0005
R109 VDD.n5 VDD 4.21975
R110 VDD.n37 VDD.n36 15.0005
R111 VDD VDD.n37 15.0005
R112 VDD.n29 VDD.n28 15.0005
R113 VDD VDD.n11 4.21975
R114 VDD.n39 VDD.n38 15.0005
R115 VDD.n38 VDD.n11 6.5635
R116 VDD.n40 VDD.n26 15.0005
R117 VDD.n26 VDD 15.0005
R118 VDD.n42 VDD.n41 15.0005
R119 VDD.n7 VDD.n42 6.5635
R120 VDD.n27 VDD.n6 15.0005
R121 VDD VDD.n7 4.21975
R122 VDD.n44 VDD.n43 15.0005
R123 VDD.n43 VDD.n8 6.5635
R124 VDD.n45 VDD.n24 15.0005
R125 VDD.n8 VDD 4.21975
R126 VDD.n47 VDD.n46 15.0005
R127 VDD VDD.n47 15.0005
R128 VDD.n25 VDD.n23 15.0005
R129 VDD VDD.n9 4.21975
R130 VDD.n48 VDD.n21 15.0005
R131 VDD.n48 VDD.n9 6.5635
R132 VDD.n50 VDD.n49 15.0005
R133 VDD.n49 VDD.n4 5.18282
R134 VDD.n51 VDD.n50 15.0005
R135 VDD.n2 VDD.n0 4.21975
R136 VDD.n4 VDD.n0 4.91009
R137 VDD.n16 VDD 15.0005
R138 VDD.n3 VDD.n17 15.0005
R139 VDD.n3 VDD.n18 15.0005
R140 VDD.n53 VDD.n15 15.0005
R141 VDD.n53 VDD.n52 15.0005
R142 VDD.n20 VDD.n1 13.0955
R143 VDD VDD.t3 10.895
R144 VDD VDD.t7 10.895
R145 VDD VDD.t5 10.8927
R146 VDD VDD.t1 10.8927
R147 VDD.n52 VDD.n19 6.64275
R148 VDD.n51 VDD.n1 6.64275
R149 VDD.n2 VDD.n22 13.1265
R150 VDD.n18 VDD.n14 6.5635
R151 VDD.n17 VDD.n14 6.5635
R152 VDD.n19 VDD.n15 6.53249
R153 VDD.n16 VDD.n12 5.18282
R154 VDD.n56 VDD.n12 5.18282
R155 VDD.n53 VDD.n12 4.91009
R156 VDD.n0 VDD.n1 4.52391
R157 VDD.n19 VDD.n3 4.52391
R158 VDD.n50 VDD.n20 4.21975
R159 VDD.n50 VDD.n22 4.21975
R160 VDD.n53 VDD.n14 4.21975
R161 VDD.n30 VDD.t11 3.03552
R162 VDD.n30 VDD.t13 3.03552
R163 VDD VDD.n0 1.40103
R164 VDD.n3 VDD 1.40103
R165 VSS.n53 VSS.n52 625.115
R166 VSS.n56 VSS.n55 513.399
R167 VSS.n32 VSS.n31 513.399
R168 VSS.n33 VSS.n32 513.399
R169 VSS.n33 VSS.n30 513.399
R170 VSS.n37 VSS.n36 513.399
R171 VSS.n37 VSS.n27 513.399
R172 VSS.n41 VSS.n40 513.399
R173 VSS.n42 VSS.n41 513.399
R174 VSS.n42 VSS.n24 513.399
R175 VSS.n46 VSS.n45 513.399
R176 VSS.n47 VSS.n46 513.399
R177 VSS.n47 VSS.n20 513.399
R178 VSS.n27 VSS.t0 504.231
R179 VSS.n56 VSS.t3 398.801
R180 VSS.n30 VSS.t5 261.284
R181 VSS.n24 VSS.t1 261.284
R182 VSS.n36 VSS.t5 252.117
R183 VSS.n45 VSS.t1 252.117
R184 VSS.n31 VSS.t3 114.599
R185 VSS.n48 VSS.n11 6.5635
R186 VSS.n39 VSS.n25 23.3338
R187 VSS.n39 VSS.n23 23.3338
R188 VSS.n43 VSS.n10 6.5635
R189 VSS.n43 VSS.n15 23.3338
R190 VSS.n34 VSS.n16 23.3338
R191 VSS.n57 VSS.n19 23.3338
R192 VSS.n48 VSS.n17 22.6988
R193 VSS.n38 VSS.n12 6.46182
R194 VSS.n34 VSS.n14 6.32546
R195 VSS.n57 VSS.n18 21.4287
R196 VSS.n44 VSS.n13 6.1077
R197 VSS.n35 VSS.n8 6.1077
R198 VSS.n4 VSS.n17 6.45409
R199 VSS.n38 VSS.n0 16.9885
R200 VSS.n9 VSS.n19 15.8338
R201 VSS.n49 VSS.n21 15.8338
R202 VSS VSS.n53 15.2537
R203 VSS.n52 VSS 15.2537
R204 VSS.n57 VSS.n56 15.0005
R205 VSS VSS.n57 15.0005
R206 VSS.n55 VSS.n19 15.0005
R207 VSS.n19 VSS 15.0005
R208 VSS.n32 VSS.n29 15.0005
R209 VSS.n29 VSS.n14 6.32546
R210 VSS.n31 VSS.n18 15.0005
R211 VSS.n2 VSS 3.6097
R212 VSS.n30 VSS.n16 15.0005
R213 VSS.n8 VSS.n16 6.1077
R214 VSS.n34 VSS.n33 15.0005
R215 VSS VSS.n14 4.33877
R216 VSS.n38 VSS.n37 15.0005
R217 VSS VSS.n12 4.27059
R218 VSS.n36 VSS.n35 15.0005
R219 VSS.n8 VSS 4.44765
R220 VSS.n24 VSS.n15 15.0005
R221 VSS.n13 VSS.n15 6.1077
R222 VSS.n43 VSS.n42 15.0005
R223 VSS VSS.n10 4.21975
R224 VSS.n41 VSS.n23 15.0005
R225 VSS.n23 VSS.n10 6.5635
R226 VSS.n40 VSS.n39 15.0005
R227 VSS.n39 VSS 15.0005
R228 VSS.n27 VSS.n25 15.0005
R229 VSS.n12 VSS.n25 6.46182
R230 VSS.n46 VSS.n17 15.0005
R231 VSS VSS.n4 2.84997
R232 VSS.n45 VSS.n44 15.0005
R233 VSS.n13 VSS 4.44765
R234 VSS.n21 VSS.n20 15.0005
R235 VSS.n11 VSS.n21 6.5635
R236 VSS.n48 VSS.n47 15.0005
R237 VSS VSS.n11 4.21975
R238 VSS.n7 VSS 4.21975
R239 VSS.n50 VSS.n7 13.1265
R240 VSS.n49 VSS 15.0005
R241 VSS VSS.n9 15.0005
R242 VSS VSS.n6 4.21975
R243 VSS.n29 VSS.n1 11.5668
R244 VSS.n3 VSS.t2 10.9505
R245 VSS.n0 VSS.t6 10.5005
R246 VSS.n1 VSS.t4 10.5005
R247 VSS.n40 VSS.t0 9.16834
R248 VSS.n2 VSS.n18 4.17491
R249 VSS.n2 VSS.n1 2.08796
R250 VSS.n0 VSS 7.5005
R251 VSS.n4 VSS.n3 3.22754
R252 VSS.n0 VSS.n26 6.6005
R253 VSS.n53 VSS.n5 6.5635
R254 VSS.n52 VSS.n51 6.5635
R255 VSS.n54 VSS.n9 6.5635
R256 VSS.n54 VSS.n6 13.1265
R257 VSS.n6 VSS.n5 13.1265
R258 VSS.n50 VSS.n49 6.5635
R259 VSS.n51 VSS.n7 13.1265
R260 VSS.n1 VSS.n28 7.0505
R261 VSS.n3 VSS.n22 6.3005
R262 VSS.n51 VSS.n20 4.21975
R263 VSS.n50 VSS.n20 4.21975
R264 VSS.n55 VSS.n54 4.21975
R265 VSS.n55 VSS.n5 4.21975
R266 VSS.n35 VSS.n0 3.70351
R267 VSS.n44 VSS.n3 3.55351
R268 a_540_987.t2 a_540_987.n1 11.571
R269 a_540_987.n1 a_540_987.t0 11.5552
R270 a_540_987.n1 a_540_987.n0 7.5005
R271 a_540_987.n0 a_540_987.t1 3.03552
R272 a_540_987.n0 a_540_987.t3 3.03552
R273 EN_BAR.n9 EN_BAR.t2 120.001
R274 EN_BAR.n1 EN_BAR.n8 115.718
R275 EN_BAR.n5 EN_BAR.t4 85.255
R276 EN_BAR.n11 EN_BAR.n10 67.4693
R277 EN_BAR.n5 EN_BAR.t3 40.0392
R278 EN_BAR.n10 EN_BAR.n9 34.8011
R279 EN_BAR.n7 EN_BAR.n5 24.8003
R280 EN_BAR.n9 EN_BAR.n8 20.0898
R281 EN_BAR EN_BAR.n0 15.9259
R282 EN_BAR.n0 EN_BAR.n1 5.1751
R283 EN_BAR.n4 EN_BAR.n1 2.89242
R284 EN_BAR.n7 EN_BAR.n6 7.85546
R285 EN_BAR.n4 EN_BAR.n3 1.97827
R286 EN_BAR.n10 EN_BAR.n2 7.5005
R287 EN_BAR.n11 EN_BAR.n8 4.52242
R288 EN_BAR.n3 EN_BAR.t2 1.09191
R289 EN_BAR.n3 EN_BAR.n2 1.96464
R290 EN_BAR.n6 EN_BAR.t0 3.03552
R291 EN_BAR.n6 EN_BAR.t1 3.03552
R292 EN_BAR.n0 EN_BAR.t2 14.0052
R293 EN_BAR.n0 EN_BAR.n2 4.18614
R294 EN_BAR.n4 EN_BAR.n11 1.72383
R295 EN_BAR EN_BAR.n7 1.2065
C0 a_211_203r# a_629_203r# 0.11683f
C1 EN EN_BAR 0.51665f
C2 a_211_203r# A 0.31421f
C3 VDD A 0.55185f
C4 EN VDD 0.52772f
C5 Y EN 0.11881f
C6 EN_BAR VDD 0.7838f
C7 a_211_203r# VDD 0.67649f
C8 Y VSS 0.28284f
C9 EN VSS 1.33243f
C10 A VSS 0.84714f
C11 VDD VSS 5.75799f
C12 a_629_203r# VSS 0.21446f
C13 EN_BAR VSS 0.55763f
C14 EN_BAR.n5 VSS 0.12134f
C15 EN_BAR.n7 VSS 0.34806f
C16 EN_BAR.n10 VSS 0.10866f
C17 a_540_987.t0 VSS 0.18352f
C18 a_540_987.t1 VSS 0.10596f
C19 a_540_987.n1 VSS 0.43043f
C20 a_540_987.t2 VSS 0.45911f
C21 VDD.n21 VSS 0.11267f
C22 VDD.t11 VSS 0.32918f
C23 VDD.n35 VSS 0.104f
C24 VDD.n36 VSS 0.11267f
C25 VDD.n44 VSS 0.11267f
C26 VDD.n45 VSS 0.104f
C27 VDD.n50 VSS 0.182f
C28 VDD.n53 VSS 0.20366f
C29 VDD.n54 VSS 0.11267f
C30 A.n0 VSS 0.11482f
C31 A.n5 VSS 0.17053f
C32 EN.n6 VSS 0.15875f
C33 Y.t0 VSS 0.14941f
.ends
