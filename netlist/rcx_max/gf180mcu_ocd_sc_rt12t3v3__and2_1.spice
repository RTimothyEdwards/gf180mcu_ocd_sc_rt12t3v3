* NGSPICE file created from gf180mcu_ocd_sc_rt12t3v3__and2_1.ext - technology: gf180mcuD

.subckt gf180mcu_ocd_sc_rt12t3v3__and2_1 A B Y VDD VSS
X0 a_236_987.t2 A.t0 a_193_203r# VSS.t0 nfet_03v3 ad=0.3087p pd=2.015u as=0.52065p ps=3.23u w=1.02u l=0.28u
X1 VDD.t7 B.t1 a_236_987.t4 VDD.t6 pfet_03v3 ad=0.3341p pd=1.805u as=0.3341p ps=1.805u w=1.285u l=0.28u
X2 Y.t1 a_236_987.t7 VDD.t9 VDD.t8 pfet_03v3 ad=0.3341p pd=1.805u as=0.3341p ps=1.805u w=1.285u l=0.28u
X3 VDD.t11 a_236_987.t6 Y.t2 VDD.t10 pfet_03v3 ad=0.5654p pd=3.45u as=0.3341p ps=1.805u w=1.285u l=0.28u
X4 a_236_987.t0 A.t2 VDD.t3 VDD.t2 pfet_03v3 ad=0.3341p pd=1.805u as=0.3341p ps=1.805u w=1.285u l=0.28u
X5 a_236_987.t3 B.t2 VDD.t5 VDD.t4 pfet_03v3 ad=0.3341p pd=1.805u as=0.5654p ps=3.45u w=1.285u l=0.28u
X6 VDD.t1 A.t1 a_236_987.t1 VDD.t0 pfet_03v3 ad=0.3341p pd=1.805u as=0.3341p ps=1.805u w=1.285u l=0.28u
X7 a_193_203r# B.t0 VSS.t2 VSS.t1 nfet_03v3 ad=0.3087p pd=2.01u as=3.40955p ps=18.84u w=1.02u l=0.28u
X8 Y.t0 a_236_987.t5 VSS.t4 VSS.t3 nfet_03v3 ad=0.3087p pd=2.01u as=3.40955p ps=18.84u w=1.02u l=0.28u
R0 Y.n7 Y.t0 120.001
R1 Y.n1 Y.n6 115.718
R2 Y.n9 Y.n8 67.4693
R3 Y.n8 Y.n7 34.8011
R4 Y.n7 Y.n6 20.0898
R5 Y Y.n0 15.1127
R6 Y.n0 Y.n1 5.1751
R7 Y.n4 Y.n1 2.89242
R8 Y Y.n5 7.94572
R9 Y.n4 Y.n3 1.97827
R10 Y.n8 Y.n2 7.5005
R11 Y.n9 Y.n6 4.52242
R12 Y.n3 Y.t0 1.09191
R13 Y.n3 Y.n2 1.96464
R14 Y.n5 Y.t1 3.03552
R15 Y.n5 Y.t2 3.03552
R16 Y.n0 Y.t0 14.0052
R17 Y.n0 Y.n2 4.18614
R18 Y.n4 Y.n9 1.72383
R19 A.n0 A.t1 82.5005
R20 A.n0 A.t2 39.6434
R21 A A.n0 18.5137
R22 A.t0 A 18.0215
R23 B.n0 B.t1 82.5005
R24 B.n0 B.t2 39.6434
R25 B B.n0 18.7416
R26 B B.t0 17.2098
R27 VDD.n40 VDD.n39 406.705
R28 VDD.n42 VDD.n41 164.505
R29 VDD.n26 VDD.n25 164.505
R30 VDD.n30 VDD.n21 164.505
R31 VDD.n32 VDD.t10 164.505
R32 VDD.t10 VDD.n17 164.505
R33 VDD.n38 VDD.n17 164.505
R34 VDD.n42 VDD.t4 141.005
R35 VDD.n31 VDD.t0 141.005
R36 VDD.n27 VDD.t6 117.504
R37 VDD.n27 VDD.t2 117.504
R38 VDD.t8 VDD.n31 94.0029
R39 VDD.n32 VDD.t8 70.5023
R40 VDD.t6 VDD.n26 47.0017
R41 VDD.t2 VDD.n21 47.0017
R42 VDD.n25 VDD.t4 23.5011
R43 VDD.t0 VDD.n30 23.5011
R44 VDD.n36 VDD.n35 23.3338
R45 VDD.n44 VDD.n43 23.3338
R46 VDD.n43 VDD.n7 6.5635
R47 VDD.n24 VDD.n10 23.3338
R48 VDD.n28 VDD.n24 23.3338
R49 VDD.n5 VDD.n4 6.5635
R50 VDD.n29 VDD.n4 23.3338
R51 VDD.n6 VDD.n20 6.5635
R52 VDD.n33 VDD.n20 23.3338
R53 VDD.n33 VDD.n19 23.3338
R54 VDD.n8 VDD.n19 6.5635
R55 VDD.n37 VDD.n34 23.3338
R56 VDD.n13 VDD.n12 23.3338
R57 VDD.n2 VDD.n9 11.7458
R58 VDD.n3 VDD.n18 11.7458
R59 VDD VDD.n23 15.256
R60 VDD VDD.n44 15.0005
R61 VDD.n43 VDD.n42 15.0005
R62 VDD.n7 VDD 4.21975
R63 VDD.n25 VDD.n10 15.0005
R64 VDD.n7 VDD.n10 6.5635
R65 VDD.n26 VDD.n24 15.0005
R66 VDD.n24 VDD 15.0005
R67 VDD.n28 VDD.n27 15.0005
R68 VDD.n5 VDD.n28 6.5635
R69 VDD.n4 VDD.n21 15.0005
R70 VDD VDD.n5 4.21975
R71 VDD.n30 VDD.n29 15.0005
R72 VDD.n29 VDD.n6 6.5635
R73 VDD.n31 VDD.n20 15.0005
R74 VDD.n6 VDD 4.21975
R75 VDD.n33 VDD.n32 15.0005
R76 VDD VDD.n33 15.0005
R77 VDD.t10 VDD.n19 15.0005
R78 VDD VDD.n8 4.21975
R79 VDD.n34 VDD.n17 15.0005
R80 VDD.n34 VDD.n8 6.5635
R81 VDD.n38 VDD.n37 15.0005
R82 VDD.n37 VDD.n3 5.18282
R83 VDD.n39 VDD.n38 15.0005
R84 VDD.n35 VDD.n1 15.0005
R85 VDD VDD.n36 15.0005
R86 VDD.n3 VDD 4.91009
R87 VDD.n2 VDD.n0 4.21975
R88 VDD.n0 VDD.n13 15.0005
R89 VDD.n41 VDD.n12 15.0005
R90 VDD.n41 VDD.n40 15.0005
R91 VDD.n16 VDD.n15 13.0955
R92 VDD VDD.t5 10.895
R93 VDD VDD.t11 10.8927
R94 VDD VDD.n22 7.85998
R95 VDD.n40 VDD.n14 6.64275
R96 VDD.n39 VDD.n15 6.64275
R97 VDD.n35 VDD.n16 6.5635
R98 VDD.n36 VDD.n18 6.5635
R99 VDD.n13 VDD.n11 6.5635
R100 VDD.n2 VDD.n11 13.1265
R101 VDD.n14 VDD.n12 6.53249
R102 VDD.n44 VDD.n9 5.18282
R103 VDD.n41 VDD.n9 4.91009
R104 VDD.n1 VDD.n15 4.52391
R105 VDD.n14 VDD.n0 4.52391
R106 VDD.n38 VDD.n16 4.21975
R107 VDD.n38 VDD.n18 4.21975
R108 VDD.n41 VDD.n11 4.21975
R109 VDD.n22 VDD.t1 3.03552
R110 VDD.n22 VDD.t9 3.03552
R111 VDD.n23 VDD.t7 3.03552
R112 VDD.n23 VDD.t3 3.03552
R113 VDD VDD.n0 1.30397
R114 VDD VDD.n1 1.01277
R115 VSS.n41 VSS.n40 513.399
R116 VSS.n26 VSS.n23 513.399
R117 VSS.n27 VSS.n26 513.399
R118 VSS.n28 VSS.n27 513.399
R119 VSS.n31 VSS.n21 513.399
R120 VSS.n32 VSS.n31 513.399
R121 VSS.n33 VSS.n20 513.399
R122 VSS.n20 VSS.n17 513.399
R123 VSS.t0 VSS.n21 467.56
R124 VSS.n38 VSS.n37 434.205
R125 VSS.n41 VSS.t1 316.291
R126 VSS.n33 VSS.t3 316.291
R127 VSS.n23 VSS.t1 197.109
R128 VSS.t3 VSS.n32 197.109
R129 VSS.n28 VSS.t0 45.8397
R130 VSS.n29 VSS.n22 23.3338
R131 VSS.n12 VSS.n11 6.5635
R132 VSS.n30 VSS.n11 23.3338
R133 VSS.n42 VSS.n16 23.3338
R134 VSS.n13 VSS.n15 6.55913
R135 VSS.n2 VSS.n14 6.524
R136 VSS.n25 VSS.n22 22.3675
R137 VSS.n42 VSS.n4 20.9317
R138 VSS.n0 VSS.n15 20.2415
R139 VSS.n3 VSS.n2 19.5186
R140 VSS.n10 VSS.n16 15.8338
R141 VSS.n34 VSS.n18 15.8338
R142 VSS VSS.n38 15.2537
R143 VSS.n37 VSS.n1 15.2537
R144 VSS.n42 VSS.n41 15.0005
R145 VSS VSS.n42 15.0005
R146 VSS.n40 VSS.n16 15.0005
R147 VSS.n16 VSS 15.0005
R148 VSS.n26 VSS.n25 15.0005
R149 VSS.n6 VSS 3.01553
R150 VSS.n23 VSS.n4 15.0005
R151 VSS.n4 VSS 15.0005
R152 VSS.n32 VSS.n15 15.0005
R153 VSS VSS.n13 4.22194
R154 VSS.n31 VSS.n30 15.0005
R155 VSS.n30 VSS.n13 6.55913
R156 VSS.n11 VSS.n21 15.0005
R157 VSS VSS.n12 4.21975
R158 VSS.n29 VSS.n28 15.0005
R159 VSS.n12 VSS.n29 6.5635
R160 VSS.n27 VSS.n22 15.0005
R161 VSS.n22 VSS 15.0005
R162 VSS.n0 VSS.n33 15.0005
R163 VSS.n0 VSS 4.75327
R164 VSS.n18 VSS.n17 15.0005
R165 VSS.n14 VSS.n18 6.524
R166 VSS.n20 VSS.n2 15.0005
R167 VSS VSS.n14 4.2395
R168 VSS.n9 VSS.n1 4.21975
R169 VSS.n35 VSS.n9 13.1265
R170 VSS.n34 VSS 15.0005
R171 VSS VSS.n10 15.0005
R172 VSS VSS.n8 4.21975
R173 VSS.n25 VSS.n6 5.95742
R174 VSS.n3 VSS.t4 10.5005
R175 VSS.n5 VSS.t2 10.5005
R176 VSS.n6 VSS.n5 2.97921
R177 VSS.n3 VSS.n19 6.6005
R178 VSS.n5 VSS.n24 6.6005
R179 VSS.n38 VSS.n7 6.5635
R180 VSS.n37 VSS.n36 6.5635
R181 VSS.n39 VSS.n10 6.5635
R182 VSS.n39 VSS.n8 13.1265
R183 VSS.n8 VSS.n7 13.1265
R184 VSS.n35 VSS.n34 6.5635
R185 VSS.n36 VSS.n9 13.1265
R186 VSS.n5 VSS.n4 5.87219
R187 VSS.n36 VSS.n17 4.21975
R188 VSS.n35 VSS.n17 4.21975
R189 VSS.n40 VSS.n39 4.21975
R190 VSS.n40 VSS.n7 4.21975
R191 VSS VSS.n1 1.38176
R192 VSS.n0 VSS.n3 1.11628
R193 a_236_987.t2 a_236_987.n2 3.95079
R194 a_236_987.n9 a_236_987.t6 82.5005
R195 a_236_987.n7 a_236_987.n2 74.8279
R196 a_236_987.n9 a_236_987.t7 39.6434
R197 a_236_987.n5 a_236_987.n4 33.9756
R198 a_236_987.n0 a_236_987.t5 32.0331
R199 a_236_987.n1 a_236_987.n9 18.2148
R200 a_236_987.n0 a_236_987.n8 15.5115
R201 a_236_987.n1 a_236_987.n10 8.36867
R202 a_236_987.n11 a_236_987.n1 7.64972
R203 a_236_987.n2 a_236_987.n5 7.58585
R204 a_236_987.n7 a_236_987.n6 7.24188
R205 a_236_987.n6 a_236_987.n4 4.08533
R206 a_236_987.n8 a_236_987.n7 3.87981
R207 a_236_987.n6 a_236_987.t2 3.87981
R208 a_236_987.t2 a_236_987.n3 3.06803
R209 a_236_987.n11 a_236_987.t0 3.03552
R210 a_236_987.t1 a_236_987.n11 3.03552
R211 a_236_987.n10 a_236_987.t3 3.03552
R212 a_236_987.n10 a_236_987.t4 3.03552
R213 a_236_987.n8 a_236_987.n3 2.80941
R214 a_236_987.n4 a_236_987.n3 2.75969
R215 a_236_987.n1 a_236_987.n0 1.6645
C0 VDD B 0.44489f
C1 VDD A 0.39626f
C2 B a_193_203r# 0.10276f
C3 Y VDD 0.31197f
C4 Y VSS 0.47754f
C5 A VSS 0.83811f
C6 B VSS 0.88916f
C7 VDD VSS 4.14709f
C8 a_193_203r# VSS 0.36506f
C9 a_236_987.n0 VSS 0.37067f
C10 a_236_987.n1 VSS 0.26292f
C11 a_236_987.t2 VSS 0.1838f
C12 VSS.t2 VSS 0.11497f
C13 VSS.t4 VSS 0.10492f
C14 VDD.n38 VSS 0.15683f
C15 VDD.n41 VSS 0.15683f
C16 Y.t0 VSS 0.11495f
.ends
