* NGSPICE file created from gf180mcu_ocd_sc_rt12t3v3__dffsr_1.ext - technology: gf180mcuD

.subckt gf180mcu_ocd_sc_rt12t3v3__dffsr_1 D CLK SN RN Q QN VDD VSS
X0 R.t0 RN.t2 VDD.t25 VDD.t24 pfet_03v3 ad=0.3341p pd=1.805u as=0.3341p ps=1.805u w=1.285u l=0.28u
X1 in1.t0 CLKb a_4039_203r# VSS.t14 nfet_03v3 ad=0.3087p pd=2.01u as=0.52065p ps=3.23u w=1.02u l=0.28u
X2 in1.t5 CLKN a_2065_203r# VSS.t28 nfet_03v3 ad=0.3087p pd=2.01u as=0.52065p ps=3.23u w=1.02u l=0.28u
X3 a_4039_203r# out1 VSS.t19 VSS.t18 nfet_03v3 ad=0.3087p pd=2.01u as=2.74793p ps=14.86u w=1.02u l=0.28u
X4 QN.t0 out2 VSS.t31 VSS.t30 nfet_03v3 ad=0.3087p pd=2.01u as=2.74793p ps=14.86u w=1.02u l=0.28u
X5 VDD.t21 CLK.t1 CLKN VDD.t20 pfet_03v3 ad=0.3341p pd=1.805u as=0.3341p ps=1.805u w=1.285u l=0.28u
X6 a_3938_987.t1 out1 VDD.t33 VDD.t32 pfet_03v3 ad=0.3341p pd=1.805u as=0.3341p ps=1.805u w=1.285u l=0.28u
X7 a_5474_987.t1 R.t5 out2 VDD.t6 pfet_03v3 ad=0.5654p pd=3.45u as=0.3341p ps=1.805u w=1.285u l=0.28u
X8 VDD.t61 out2 a_6694_987.t2 VDD.t60 pfet_03v3 ad=0.3341p pd=1.805u as=0.5654p ps=3.45u w=1.285u l=0.28u
X9 a_4706_987.t1 out1 VDD.t39 VDD.t38 pfet_03v3 ad=0.3341p pd=1.805u as=0.3341p ps=1.805u w=1.285u l=0.28u
X10 a_2065_203r# D.t0 VSS.t5 VSS.t4 nfet_03v3 ad=0.3087p pd=2.01u as=2.9769p ps=16.1u w=1.02u l=0.28u
X11 out1 SNb a_2824_203r# VSS.t34 nfet_03v3 ad=0.3087p pd=2.01u as=0.52065p ps=3.23u w=1.02u l=0.28u
X12 VDD.t5 D.t2 a_1948_987.t0 VDD.t4 pfet_03v3 ad=0.3341p pd=1.805u as=0.5654p ps=3.45u w=1.285u l=0.28u
X13 VDD.t65 SNb a_2717_987.t4 VDD.t64 pfet_03v3 ad=0.3341p pd=1.805u as=0.5654p ps=3.45u w=1.285u l=0.28u
X14 a_1948_987.t2 CLKb in1.t2 VDD.t27 pfet_03v3 ad=0.5654p pd=3.45u as=0.3341p ps=1.805u w=1.285u l=0.28u
X15 a_2717_987.t1 R.t7 out1 VDD.t13 pfet_03v3 ad=0.5654p pd=3.45u as=0.3341p ps=1.805u w=1.285u l=0.28u
X16 VDD.t43 SN.t1 a_921_203r# VDD.t42 pfet_03v3 ad=0.3341p pd=1.805u as=0.3341p ps=1.805u w=1.285u l=0.28u
X17 in2.t3 CLKN a_4706_987.t3 VDD.t54 pfet_03v3 ad=0.3341p pd=1.805u as=0.3341p ps=1.805u w=1.285u l=0.28u
X18 VDD.t63 out2 QN.t1 VDD.t62 pfet_03v3 ad=0.3341p pd=1.805u as=0.3341p ps=1.805u w=1.285u l=0.28u
X19 a_6795_203r# out2 VSS.t33 VSS.t32 nfet_03v3 ad=0.3087p pd=2.01u as=2.74793p ps=14.86u w=1.02u l=0.28u
X20 a_1948_987.t1 D.t1 VDD.t3 VDD.t2 pfet_03v3 ad=0.3341p pd=1.805u as=0.3341p ps=1.805u w=1.285u l=0.28u
X21 SNb a_921_203r# VSS.t25 VSS.t24 nfet_03v3 ad=0.3087p pd=2.01u as=2.9769p ps=16.1u w=1.02u l=0.28u
X22 a_2824_203r# in1.t6 VSS.t21 VSS.t20 nfet_03v3 ad=0.3087p pd=2.015u as=2.9769p ps=16.1u w=1.02u l=0.28u
X23 VDD.t31 in1.t8 a_2717_987.t3 VDD.t30 pfet_03v3 ad=0.3341p pd=1.805u as=0.5654p ps=3.45u w=1.285u l=0.28u
X24 VDD.t69 SNb a_5474_987.t4 VDD.t68 pfet_03v3 ad=0.3341p pd=1.805u as=0.5654p ps=3.45u w=1.285u l=0.28u
X25 CLKN CLK.t0 VSS.t11 VSS.t10 nfet_03v3 ad=0.3087p pd=2.01u as=2.9769p ps=16.1u w=1.02u l=0.28u
X26 SNb a_921_203r# VDD.t45 VDD.t44 pfet_03v3 ad=0.3341p pd=1.805u as=0.3341p ps=1.805u w=1.285u l=0.28u
X27 VDD.t23 RN.t1 R.t1 VDD.t22 pfet_03v3 ad=0.5654p pd=3.45u as=0.3341p ps=1.805u w=1.285u l=0.28u
X28 a_4706_987.t2 CLKN in2.t4 VDD.t55 pfet_03v3 ad=0.5654p pd=3.45u as=0.3341p ps=1.805u w=1.285u l=0.28u
X29 VDD.t12 in2.t8 a_5474_987.t2 VDD.t11 pfet_03v3 ad=0.3341p pd=1.805u as=0.5654p ps=3.45u w=1.285u l=0.28u
X30 Q.t1 QN.t5 VDD.t8 VDD.t7 pfet_03v3 ad=0.3341p pd=1.805u as=0.3341p ps=1.805u w=1.285u l=0.28u
X31 a_5574_203r# in2.t6 VSS.t9 VSS.t8 nfet_03v3 ad=0.3087p pd=2.015u as=2.9769p ps=16.1u w=1.02u l=0.28u
X32 CLKb CLKN VDD.t49 VDD.t48 pfet_03v3 ad=0.3341p pd=1.805u as=0.3341p ps=1.805u w=1.285u l=0.28u
X33 a_5474_987.t5 SNb VDD.t71 VDD.t70 pfet_03v3 ad=0.3341p pd=1.805u as=0.3341p ps=1.805u w=1.285u l=0.28u
X34 a_2717_987.t2 in1.t7 VDD.t17 VDD.t16 pfet_03v3 ad=0.5654p pd=3.45u as=0.3341p ps=1.805u w=1.285u l=0.28u
X35 in1.t3 CLKN a_3938_987.t2 VDD.t52 pfet_03v3 ad=0.3341p pd=1.805u as=0.3341p ps=1.805u w=1.285u l=0.28u
X36 a_6694_987.t3 out2 VDD.t59 VDD.t58 pfet_03v3 ad=0.3341p pd=1.805u as=0.3341p ps=1.805u w=1.285u l=0.28u
X37 out2 SNb a_5574_203r# VSS.t35 nfet_03v3 ad=0.3087p pd=2.01u as=0.52065p ps=3.23u w=1.02u l=0.28u
X38 a_2717_987.t5 SNb VDD.t67 VDD.t66 pfet_03v3 ad=0.3341p pd=1.805u as=0.3341p ps=1.805u w=1.285u l=0.28u
X39 VDD.t10 QN.t4 Q.t0 VDD.t9 pfet_03v3 ad=0.5654p pd=3.45u as=0.3341p ps=1.805u w=1.285u l=0.28u
X40 a_921_203r# SN.t0 VSS.t23 VSS.t22 nfet_03v3 ad=0.3087p pd=2.01u as=2.9769p ps=16.1u w=1.02u l=0.28u
X41 Q.t2 QN.t3 VSS.t7 VSS.t6 nfet_03v3 ad=0.3087p pd=2.01u as=2.9769p ps=16.1u w=1.02u l=0.28u
X42 CLKN CLK.t2 VDD.t19 VDD.t18 pfet_03v3 ad=0.3341p pd=1.805u as=0.5654p ps=3.45u w=1.285u l=0.28u
X43 VDD.t51 CLKN CLKb VDD.t50 pfet_03v3 ad=0.5654p pd=3.45u as=0.3341p ps=1.805u w=1.285u l=0.28u
X44 VDD.t37 out1 a_4706_987.t0 VDD.t36 pfet_03v3 ad=0.3341p pd=1.805u as=0.5654p ps=3.45u w=1.285u l=0.28u
X45 in2.t0 CLKb a_6694_987.t0 VDD.t28 pfet_03v3 ad=0.3341p pd=1.805u as=0.3341p ps=1.805u w=1.285u l=0.28u
X46 CLKb CLKN VSS.t27 VSS.t26 nfet_03v3 ad=0.3087p pd=2.01u as=2.9769p ps=16.1u w=1.02u l=0.28u
X47 out1 R.t4 VSS.t3 VSS.t2 nfet_03v3 ad=0.3087p pd=2.01u as=2.74793p ps=14.86u w=1.02u l=0.28u
X48 a_921_203r# SN.t2 VDD.t41 VDD.t40 pfet_03v3 ad=0.3341p pd=1.805u as=0.5654p ps=3.45u w=1.285u l=0.28u
X49 in1.t1 CLKb a_1948_987.t3 VDD.t26 pfet_03v3 ad=0.3341p pd=1.805u as=0.3341p ps=1.805u w=1.285u l=0.28u
X50 out1 R.t8 a_2717_987.t0 VDD.t1 pfet_03v3 ad=0.3341p pd=1.805u as=0.3341p ps=1.805u w=1.285u l=0.28u
X51 in2.t2 CLKb a_4807_203r# VSS.t15 nfet_03v3 ad=0.3087p pd=2.01u as=0.52065p ps=3.23u w=1.02u l=0.28u
X52 VDD.t47 a_921_203r# SNb VDD.t46 pfet_03v3 ad=0.3341p pd=1.805u as=0.3341p ps=1.805u w=1.285u l=0.28u
X53 a_4807_203r# out1 VSS.t17 VSS.t16 nfet_03v3 ad=0.3087p pd=2.01u as=2.74793p ps=14.86u w=1.02u l=0.28u
X54 a_5474_987.t3 in2.t7 VDD.t15 VDD.t14 pfet_03v3 ad=0.5654p pd=3.45u as=0.3341p ps=1.805u w=1.285u l=0.28u
X55 a_6694_987.t1 CLKb in2.t1 VDD.t29 pfet_03v3 ad=0.5654p pd=3.45u as=0.3341p ps=1.805u w=1.285u l=0.28u
X56 QN.t2 out2 VDD.t57 VDD.t56 pfet_03v3 ad=0.3341p pd=1.805u as=0.5654p ps=3.45u w=1.285u l=0.28u
X57 R.t2 RN.t0 VSS.t13 VSS.t12 nfet_03v3 ad=0.3087p pd=2.015u as=2.9769p ps=16.1u w=1.02u l=0.28u
X58 out2 R.t3 VSS.t1 VSS.t0 nfet_03v3 ad=0.3087p pd=2.01u as=2.74793p ps=14.86u w=1.02u l=0.28u
X59 in2.t5 CLKN a_6795_203r# VSS.t29 nfet_03v3 ad=0.3087p pd=2.01u as=0.53235p ps=3.25u w=1.02u l=0.28u
X60 VDD.t35 out1 a_3938_987.t0 VDD.t34 pfet_03v3 ad=0.3341p pd=1.805u as=0.5654p ps=3.45u w=1.285u l=0.28u
X61 a_3938_987.t3 CLKN in1.t4 VDD.t53 pfet_03v3 ad=0.5654p pd=3.45u as=0.3341p ps=1.805u w=1.285u l=0.28u
X62 out2 R.t6 a_5474_987.t0 VDD.t0 pfet_03v3 ad=0.3341p pd=1.805u as=0.3341p ps=1.805u w=1.285u l=0.28u
R0 Q.n7 Q.t2 120.001
R1 Q.n1 Q.n6 115.718
R2 Q.n9 Q.n8 67.4693
R3 Q.n8 Q.n7 34.8011
R4 Q.n7 Q.n6 20.0898
R5 Q Q.n0 15.3213
R6 Q.n0 Q.n1 5.1751
R7 Q.n4 Q.n1 2.89242
R8 Q Q.n5 7.87735
R9 Q.n4 Q.n3 1.97827
R10 Q.n8 Q.n2 7.5005
R11 Q.n9 Q.n6 4.52242
R12 Q.n3 Q.t2 1.09191
R13 Q.n3 Q.n2 1.96464
R14 Q.n5 Q.t1 3.03552
R15 Q.n5 Q.t0 3.03552
R16 Q.n0 Q.t2 14.0052
R17 Q.n0 Q.n2 4.18614
R18 Q.n4 Q.n9 1.72383
R19 QN.n8 QN.t0 120.001
R20 QN.n1 QN.n7 115.718
R21 QN.n6 QN.t4 85.566
R22 QN.n6 QN.t5 78.4826
R23 QN.n10 QN.n9 67.4693
R24 QN.n9 QN.n8 34.8011
R25 QN.n8 QN.n7 20.0898
R26 QN QN.n0 15.4443
R27 QN.n0 QN.n1 5.1751
R28 QN.n4 QN.n1 2.89242
R29 QN QN.n5 7.87887
R30 QN QN.n6 7.71528
R31 QN.n4 QN.n3 1.97827
R32 QN.n9 QN.n2 7.5005
R33 QN QN.t3 12.6231
R34 QN.n10 QN.n7 4.52242
R35 QN.n3 QN.t0 1.09191
R36 QN.n3 QN.n2 1.96464
R37 QN.n5 QN.t2 3.03552
R38 QN.n5 QN.t1 3.03552
R39 QN.n0 QN.t0 14.0052
R40 QN.n0 QN.n2 4.18614
R41 QN.n4 QN.n10 1.72383
R42 D.n0 D.t1 64.435
R43 D.n0 D.t2 48.185
R44 D D.n0 38.4976
R45 D D.t0 13.3928
R46 RN.n0 RN.t1 102.858
R47 RN.n0 RN.t2 60.0005
R48 RN RN.n0 49.016
R49 RN.t0 RN 22.6801
R50 SN.n0 SN.t1 101.525
R51 SN.n0 SN.t2 59.8858
R52 SN SN.t0 43.8922
R53 SN SN.n0 22.0802
R54 CLK.n0 CLK.t1 82.5005
R55 CLK.n0 CLK.t2 39.6434
R56 CLK CLK.n0 39.1058
R57 CLK CLK.t0 13.4212
R58 VDD.n205 VDD.n204 2812.16
R59 VDD.n207 VDD.n206 164.505
R60 VDD.n115 VDD.n114 164.505
R61 VDD.n119 VDD.n118 164.505
R62 VDD.n120 VDD.n110 164.505
R63 VDD.n124 VDD.n123 164.505
R64 VDD.t46 VDD.n104 164.505
R65 VDD.n128 VDD.t46 164.505
R66 VDD.n132 VDD.n101 164.505
R67 VDD.n133 VDD.n132 164.505
R68 VDD.n137 VDD.n97 164.505
R69 VDD.n139 VDD.n95 164.505
R70 VDD.n142 VDD.n95 164.505
R71 VDD.n144 VDD.n92 164.505
R72 VDD.n147 VDD.n92 164.505
R73 VDD.n149 VDD.n91 164.505
R74 VDD.n154 VDD.n153 164.505
R75 VDD.n154 VDD.n89 164.505
R76 VDD.n159 VDD.n158 164.505
R77 VDD.n163 VDD.n162 164.505
R78 VDD.n164 VDD.n163 164.505
R79 VDD.n169 VDD.n168 164.505
R80 VDD.n172 VDD.n77 164.505
R81 VDD.n174 VDD.n173 164.505
R82 VDD.n177 VDD.n73 164.505
R83 VDD.n179 VDD.n178 164.505
R84 VDD.n183 VDD.n182 164.505
R85 VDD.n184 VDD.n69 164.505
R86 VDD.n188 VDD.n187 164.505
R87 VDD.n192 VDD.n64 164.505
R88 VDD.n194 VDD.n193 164.505
R89 VDD.n197 VDD.n61 164.505
R90 VDD.n60 VDD.n56 164.505
R91 VDD.n203 VDD.n56 164.505
R92 VDD.t52 VDD.n85 155.692
R93 VDD.t36 VDD.n82 155.692
R94 VDD.t68 VDD.n177 155.692
R95 VDD.n199 VDD.t9 155.692
R96 VDD.t54 VDD.n167 149.816
R97 VDD.t11 VDD.n172 149.816
R98 VDD.n193 VDD.t29 149.816
R99 VDD.n198 VDD.t62 149.816
R100 VDD.n207 VDD.t18 141.005
R101 VDD.n120 VDD.t50 141.005
R102 VDD.n125 VDD.t42 141.005
R103 VDD.n129 VDD.t22 141.005
R104 VDD.n134 VDD.t2 141.005
R105 VDD.n152 VDD.t1 132.191
R106 VDD.n157 VDD.t34 132.191
R107 VDD.n72 VDD.t0 132.191
R108 VDD.n69 VDD.t60 132.191
R109 VDD.t66 VDD.n148 126.317
R110 VDD.n184 VDD.t6 126.317
R111 VDD.n189 VDD.t58 126.317
R112 VDD.t16 VDD.n143 118.972
R113 VDD.t20 VDD.n113 117.504
R114 VDD.n113 VDD.t48 117.504
R115 VDD.n110 VDD.t40 117.504
R116 VDD.n138 VDD.t26 117.504
R117 VDD.t27 VDD.n138 117.504
R118 VDD.n143 VDD.t30 116.034
R119 VDD.n148 VDD.t64 108.691
R120 VDD.t55 VDD.n77 108.691
R121 VDD.t14 VDD.n73 108.691
R122 VDD.n189 VDD.t28 108.691
R123 VDD.n194 VDD.t56 108.691
R124 VDD.t13 VDD.n152 102.816
R125 VDD.t32 VDD.n157 102.816
R126 VDD.t70 VDD.n72 102.816
R127 VDD.n125 VDD.t44 94.0029
R128 VDD.n129 VDD.t24 94.0029
R129 VDD.n134 VDD.t4 94.0029
R130 VDD.n162 VDD.t53 85.1902
R131 VDD.n167 VDD.t38 85.1902
R132 VDD.t7 VDD.n198 85.1902
R133 VDD.n85 VDD.t53 79.3151
R134 VDD.n82 VDD.t38 79.3151
R135 VDD.n199 VDD.t7 79.3151
R136 VDD.t44 VDD.n104 70.5023
R137 VDD.t24 VDD.n128 70.5023
R138 VDD.t4 VDD.n133 70.5023
R139 VDD.n153 VDD.t13 61.6896
R140 VDD.n158 VDD.t32 61.6896
R141 VDD.n179 VDD.t70 61.6896
R142 VDD.t64 VDD.n147 55.8145
R143 VDD.n169 VDD.t55 55.8145
R144 VDD.n174 VDD.t14 55.8145
R145 VDD.t28 VDD.n64 55.8145
R146 VDD.t56 VDD.n61 55.8145
R147 VDD.t30 VDD.n142 48.4705
R148 VDD.n115 VDD.t20 47.0017
R149 VDD.n118 VDD.t48 47.0017
R150 VDD.n123 VDD.t40 47.0017
R151 VDD.t26 VDD.n137 47.0017
R152 VDD.n139 VDD.t27 47.0017
R153 VDD.n144 VDD.t16 45.5329
R154 VDD.n149 VDD.t66 38.189
R155 VDD.t6 VDD.n183 38.189
R156 VDD.t58 VDD.n188 38.189
R157 VDD.n91 VDD.t1 32.3138
R158 VDD.n89 VDD.t34 32.3138
R159 VDD.n182 VDD.t0 32.3138
R160 VDD.n187 VDD.t60 32.3138
R161 VDD.n114 VDD.t18 23.5011
R162 VDD.t50 VDD.n119 23.5011
R163 VDD.t42 VDD.n124 23.5011
R164 VDD.t22 VDD.n101 23.5011
R165 VDD.t2 VDD.n97 23.5011
R166 VDD.n6 VDD.n55 13.1265
R167 VDD.n209 VDD.n208 23.3338
R168 VDD.n208 VDD.n37 6.5635
R169 VDD.n116 VDD.n50 23.3338
R170 VDD.n116 VDD.n111 23.3338
R171 VDD.n117 VDD.n12 6.5635
R172 VDD.n117 VDD.n109 23.3338
R173 VDD.n121 VDD.n36 6.5635
R174 VDD.n121 VDD.n108 23.3338
R175 VDD.n122 VDD.n13 6.5635
R176 VDD.n122 VDD.n107 23.3338
R177 VDD.n126 VDD.n35 6.5635
R178 VDD.n126 VDD.n14 23.3338
R179 VDD.n127 VDD.n14 23.3338
R180 VDD.n40 VDD.n103 6.5635
R181 VDD.n130 VDD.n103 23.3338
R182 VDD.n130 VDD.n102 23.3338
R183 VDD.n44 VDD.n102 6.5635
R184 VDD.n131 VDD.n100 23.3338
R185 VDD.n135 VDD.n100 23.3338
R186 VDD.n135 VDD.n34 6.5635
R187 VDD.n136 VDD.n98 23.3338
R188 VDD.n15 VDD.n96 6.5635
R189 VDD.n140 VDD.n96 23.3338
R190 VDD.n17 VDD.n16 6.5635
R191 VDD.n141 VDD.n16 23.3338
R192 VDD.n141 VDD.n48 23.3338
R193 VDD.n30 VDD.n48 6.5635
R194 VDD.n145 VDD.n93 23.3338
R195 VDD.n10 VDD.n93 6.5635
R196 VDD.n146 VDD.n47 23.3338
R197 VDD.n32 VDD.n47 6.5635
R198 VDD.n150 VDD.n9 23.3338
R199 VDD.n151 VDD.n9 23.3338
R200 VDD.n18 VDD.n88 6.5635
R201 VDD.n155 VDD.n88 23.3338
R202 VDD.n155 VDD.n86 23.3338
R203 VDD.n33 VDD.n86 6.5635
R204 VDD.n156 VDD.n84 23.3338
R205 VDD.n19 VDD.n84 6.5635
R206 VDD.n160 VDD.n83 23.3338
R207 VDD.n161 VDD.n20 6.5635
R208 VDD.n161 VDD.n81 23.3338
R209 VDD.n165 VDD.n81 23.3338
R210 VDD.n165 VDD.n39 6.5635
R211 VDD.n166 VDD.n46 23.3338
R212 VDD.n166 VDD.n79 23.3338
R213 VDD.n170 VDD.n21 6.5635
R214 VDD.n170 VDD.n78 23.3338
R215 VDD.n171 VDD.n22 6.5635
R216 VDD.n171 VDD.n76 23.3338
R217 VDD.n175 VDD.n43 6.5635
R218 VDD.n175 VDD.n74 23.3338
R219 VDD.n176 VDD.n23 6.5635
R220 VDD.n176 VDD.n71 23.3338
R221 VDD.n180 VDD.n42 6.5635
R222 VDD.n180 VDD.n24 23.3338
R223 VDD.n181 VDD.n24 23.3338
R224 VDD.n25 VDD.n68 6.5635
R225 VDD.n185 VDD.n68 23.3338
R226 VDD.n27 VDD.n26 6.5635
R227 VDD.n186 VDD.n26 23.3338
R228 VDD.n45 VDD.n66 6.5635
R229 VDD.n190 VDD.n66 23.3338
R230 VDD.n190 VDD.n65 23.3338
R231 VDD.n191 VDD.n28 6.5635
R232 VDD.n191 VDD.n63 23.3338
R233 VDD.n195 VDD.n31 6.5635
R234 VDD.n195 VDD.n29 23.3338
R235 VDD.n196 VDD.n29 23.3338
R236 VDD.n38 VDD.n59 6.5635
R237 VDD.n200 VDD.n59 23.3338
R238 VDD.n200 VDD.n58 23.3338
R239 VDD.n41 VDD.n58 6.5635
R240 VDD.n202 VDD.n201 23.3338
R241 VDD.n53 VDD.n52 23.3338
R242 VDD.n8 VDD.n49 11.7458
R243 VDD.n11 VDD.n57 11.7458
R244 VDD.n4 VDD.n67 15.2628
R245 VDD.n7 VDD.n70 15.2628
R246 VDD.n7 VDD.n75 15.2628
R247 VDD.n1 VDD.n80 15.2628
R248 VDD.n1 VDD.n87 15.2628
R249 VDD.n0 VDD.n90 15.2628
R250 VDD.n0 VDD.n94 15.2628
R251 VDD.n0 VDD.n99 15.2628
R252 VDD VDD.n209 15.0005
R253 VDD.n208 VDD.n207 15.0005
R254 VDD.n37 VDD 4.21975
R255 VDD.n114 VDD.n50 15.0005
R256 VDD.n37 VDD.n50 6.5635
R257 VDD.n116 VDD.n115 15.0005
R258 VDD VDD.n116 15.0005
R259 VDD.n113 VDD.n111 15.0005
R260 VDD.n12 VDD.n111 6.5635
R261 VDD.n118 VDD.n117 15.0005
R262 VDD.n12 VDD 4.21975
R263 VDD.n119 VDD.n109 15.0005
R264 VDD.n36 VDD.n109 6.5635
R265 VDD.n121 VDD.n120 15.0005
R266 VDD VDD.n36 4.21975
R267 VDD.n110 VDD.n108 15.0005
R268 VDD.n13 VDD.n108 6.5635
R269 VDD.n123 VDD.n122 15.0005
R270 VDD.n13 VDD 4.21975
R271 VDD.n124 VDD.n107 15.0005
R272 VDD.n35 VDD.n107 6.5635
R273 VDD.n126 VDD.n125 15.0005
R274 VDD.n0 VDD.n35 4.21975
R275 VDD.n14 VDD.n104 15.0005
R276 VDD.n0 VDD.n14 15.0005
R277 VDD.t46 VDD.n127 15.0005
R278 VDD.n127 VDD.n40 6.5635
R279 VDD.n128 VDD.n103 15.0005
R280 VDD.n40 VDD.n0 4.21975
R281 VDD.n130 VDD.n129 15.0005
R282 VDD.n0 VDD.n130 15.0005
R283 VDD.n102 VDD.n101 15.0005
R284 VDD.n0 VDD.n44 4.21975
R285 VDD.n132 VDD.n131 15.0005
R286 VDD.n131 VDD.n44 6.5635
R287 VDD.n133 VDD.n100 15.0005
R288 VDD.n100 VDD.n0 15.0005
R289 VDD.n135 VDD.n134 15.0005
R290 VDD.n0 VDD.n34 4.21975
R291 VDD.n98 VDD.n97 15.0005
R292 VDD.n34 VDD.n98 6.5635
R293 VDD.n137 VDD.n136 15.0005
R294 VDD.n136 VDD.n15 6.5635
R295 VDD.n138 VDD.n96 15.0005
R296 VDD.n15 VDD.n0 4.21975
R297 VDD.n140 VDD.n139 15.0005
R298 VDD.n17 VDD.n140 6.5635
R299 VDD.n16 VDD.n95 15.0005
R300 VDD.n0 VDD.n17 4.21975
R301 VDD.n142 VDD.n141 15.0005
R302 VDD.n141 VDD.n0 15.0005
R303 VDD.n143 VDD.n48 15.0005
R304 VDD.n0 VDD.n30 4.21975
R305 VDD.n145 VDD.n144 15.0005
R306 VDD.n30 VDD.n145 6.5635
R307 VDD.n93 VDD.n92 15.0005
R308 VDD.n0 VDD.n10 4.21975
R309 VDD.n147 VDD.n146 15.0005
R310 VDD.n146 VDD.n10 6.5635
R311 VDD.n148 VDD.n47 15.0005
R312 VDD.n0 VDD.n32 4.21975
R313 VDD.n150 VDD.n149 15.0005
R314 VDD.n32 VDD.n150 6.5635
R315 VDD.n91 VDD.n9 15.0005
R316 VDD.n1 VDD.n9 15.0005
R317 VDD.n152 VDD.n151 15.0005
R318 VDD.n151 VDD.n18 6.5635
R319 VDD.n153 VDD.n88 15.0005
R320 VDD.n18 VDD.n1 4.21975
R321 VDD.n155 VDD.n154 15.0005
R322 VDD.n1 VDD.n155 15.0005
R323 VDD.n89 VDD.n86 15.0005
R324 VDD.n1 VDD.n33 4.21975
R325 VDD.n157 VDD.n156 15.0005
R326 VDD.n156 VDD.n33 6.5635
R327 VDD.n158 VDD.n84 15.0005
R328 VDD.n19 VDD.n1 4.21975
R329 VDD.n160 VDD.n159 15.0005
R330 VDD.n19 VDD.n160 6.5635
R331 VDD.n85 VDD.n83 15.0005
R332 VDD.n20 VDD.n83 6.5635
R333 VDD.n162 VDD.n161 15.0005
R334 VDD.n20 VDD.n1 4.21975
R335 VDD.n163 VDD.n81 15.0005
R336 VDD.n81 VDD.n1 15.0005
R337 VDD.n165 VDD.n164 15.0005
R338 VDD.n1 VDD.n39 4.21975
R339 VDD.n82 VDD.n46 15.0005
R340 VDD.n39 VDD.n46 6.5635
R341 VDD.n167 VDD.n166 15.0005
R342 VDD.n166 VDD.n1 15.0005
R343 VDD.n168 VDD.n79 15.0005
R344 VDD.n79 VDD.n21 6.5635
R345 VDD.n170 VDD.n169 15.0005
R346 VDD.n1 VDD.n21 4.21975
R347 VDD.n78 VDD.n77 15.0005
R348 VDD.n22 VDD.n78 6.5635
R349 VDD.n172 VDD.n171 15.0005
R350 VDD.n22 VDD.n7 4.21975
R351 VDD.n173 VDD.n76 15.0005
R352 VDD.n43 VDD.n76 6.5635
R353 VDD.n175 VDD.n174 15.0005
R354 VDD.n7 VDD.n43 4.21975
R355 VDD.n74 VDD.n73 15.0005
R356 VDD.n23 VDD.n74 6.5635
R357 VDD.n177 VDD.n176 15.0005
R358 VDD.n23 VDD.n7 4.21975
R359 VDD.n178 VDD.n71 15.0005
R360 VDD.n42 VDD.n71 6.5635
R361 VDD.n180 VDD.n179 15.0005
R362 VDD.n7 VDD.n42 4.21975
R363 VDD.n72 VDD.n24 15.0005
R364 VDD.n7 VDD.n24 15.0005
R365 VDD.n182 VDD.n181 15.0005
R366 VDD.n181 VDD.n25 6.5635
R367 VDD.n183 VDD.n68 15.0005
R368 VDD.n25 VDD.n7 4.21975
R369 VDD.n185 VDD.n184 15.0005
R370 VDD.n27 VDD.n185 6.5635
R371 VDD.n69 VDD.n26 15.0005
R372 VDD.n7 VDD.n27 4.21975
R373 VDD.n187 VDD.n186 15.0005
R374 VDD.n186 VDD.n45 6.5635
R375 VDD.n188 VDD.n66 15.0005
R376 VDD.n45 VDD.n4 4.21975
R377 VDD.n190 VDD.n189 15.0005
R378 VDD.n4 VDD.n190 15.0005
R379 VDD.n65 VDD.n64 15.0005
R380 VDD.n28 VDD.n65 6.5635
R381 VDD.n192 VDD.n191 15.0005
R382 VDD.n28 VDD.n4 4.21975
R383 VDD.n193 VDD.n63 15.0005
R384 VDD.n31 VDD.n63 6.5635
R385 VDD.n195 VDD.n194 15.0005
R386 VDD.n4 VDD.n31 4.21975
R387 VDD.n29 VDD.n61 15.0005
R388 VDD.n4 VDD.n29 15.0005
R389 VDD.n197 VDD.n196 15.0005
R390 VDD.n196 VDD.n38 6.5635
R391 VDD.n198 VDD.n59 15.0005
R392 VDD.n38 VDD.n5 4.21975
R393 VDD.n200 VDD.n199 15.0005
R394 VDD.n5 VDD.n200 15.0005
R395 VDD.n60 VDD.n58 15.0005
R396 VDD.n5 VDD.n41 4.21975
R397 VDD.n201 VDD.n56 15.0005
R398 VDD.n201 VDD.n41 6.5635
R399 VDD.n203 VDD.n202 15.0005
R400 VDD.n202 VDD.n11 5.18282
R401 VDD.n204 VDD.n203 15.0005
R402 VDD.n6 VDD.n5 4.21975
R403 VDD.n11 VDD.n5 4.91009
R404 VDD.n8 VDD.n2 4.21975
R405 VDD.n2 VDD.n53 15.0005
R406 VDD.n206 VDD.n52 15.0005
R407 VDD.n206 VDD.n205 15.0005
R408 VDD.n168 VDD.t54 14.6884
R409 VDD.n173 VDD.t11 14.6884
R410 VDD.t29 VDD.n192 14.6884
R411 VDD.t62 VDD.n197 14.6884
R412 VDD.n55 VDD.n3 13.0955
R413 VDD.n4 VDD.t57 10.895
R414 VDD VDD.t19 10.895
R415 VDD VDD.t41 10.895
R416 VDD.n5 VDD.t10 10.8927
R417 VDD.n0 VDD.t23 10.8927
R418 VDD VDD.t51 10.8927
R419 VDD.n159 VDD.t52 8.81323
R420 VDD.n164 VDD.t36 8.81323
R421 VDD.n178 VDD.t68 8.81323
R422 VDD.t9 VDD.n60 8.81323
R423 VDD.n5 VDD.n62 7.85998
R424 VDD.n0 VDD.n105 7.85998
R425 VDD.n0 VDD.n106 7.85998
R426 VDD VDD.n112 7.85998
R427 VDD.n205 VDD.n54 6.64275
R428 VDD.n204 VDD.n3 6.64275
R429 VDD.n6 VDD.n57 13.1265
R430 VDD.n53 VDD.n51 6.5635
R431 VDD.n8 VDD.n51 13.1265
R432 VDD.n54 VDD.n52 6.53249
R433 VDD.n209 VDD.n49 5.18282
R434 VDD.n206 VDD.n49 4.91009
R435 VDD.n5 VDD.n3 4.52391
R436 VDD.n54 VDD.n2 4.52391
R437 VDD.n203 VDD.n55 4.21975
R438 VDD.n203 VDD.n57 4.21975
R439 VDD.n206 VDD.n51 4.21975
R440 VDD.n62 VDD.t63 3.03552
R441 VDD.n62 VDD.t8 3.03552
R442 VDD.n67 VDD.t61 3.03552
R443 VDD.n67 VDD.t59 3.03552
R444 VDD.n70 VDD.t69 3.03552
R445 VDD.n70 VDD.t71 3.03552
R446 VDD.n75 VDD.t12 3.03552
R447 VDD.n75 VDD.t15 3.03552
R448 VDD.n80 VDD.t37 3.03552
R449 VDD.n80 VDD.t39 3.03552
R450 VDD.n87 VDD.t35 3.03552
R451 VDD.n87 VDD.t33 3.03552
R452 VDD.n90 VDD.t65 3.03552
R453 VDD.n90 VDD.t67 3.03552
R454 VDD.n94 VDD.t31 3.03552
R455 VDD.n94 VDD.t17 3.03552
R456 VDD.n99 VDD.t5 3.03552
R457 VDD.n99 VDD.t3 3.03552
R458 VDD.n105 VDD.t47 3.03552
R459 VDD.n105 VDD.t25 3.03552
R460 VDD.n106 VDD.t43 3.03552
R461 VDD.n106 VDD.t45 3.03552
R462 VDD.n112 VDD.t21 3.03552
R463 VDD.n112 VDD.t49 3.03552
R464 VDD.n7 VDD.n1 1.84477
R465 VDD.n1 VDD.n0 1.65063
R466 VDD.n5 VDD.n4 1.30397
R467 VDD VDD.n2 1.30397
R468 VDD.n4 VDD.n7 1.1653
R469 VDD VDD.n0 1.1653
R470 VSS.n225 VSS.n224 2839.66
R471 VSS.n228 VSS.n227 513.399
R472 VSS.n129 VSS.n128 513.399
R473 VSS.n129 VSS.n127 513.399
R474 VSS.n133 VSS.n132 513.399
R475 VSS.n133 VSS.n123 513.399
R476 VSS.n136 VSS.n123 513.399
R477 VSS.n138 VSS.n137 513.399
R478 VSS.n138 VSS.n122 513.399
R479 VSS.n142 VSS.n141 513.399
R480 VSS.n142 VSS.n121 513.399
R481 VSS.n146 VSS.n145 513.399
R482 VSS.n146 VSS.n118 513.399
R483 VSS.n149 VSS.n118 513.399
R484 VSS.n150 VSS.n116 513.399
R485 VSS.n152 VSS.n116 513.399
R486 VSS.n154 VSS.n153 513.399
R487 VSS.n154 VSS.n114 513.399
R488 VSS.n157 VSS.n114 513.399
R489 VSS.n158 VSS.n112 513.399
R490 VSS.n161 VSS.n112 513.399
R491 VSS.n163 VSS.n162 513.399
R492 VSS.n163 VSS.n108 513.399
R493 VSS.n166 VSS.n108 513.399
R494 VSS.n168 VSS.n167 513.399
R495 VSS.n168 VSS.n107 513.399
R496 VSS.n172 VSS.n171 513.399
R497 VSS.n172 VSS.n104 513.399
R498 VSS.n175 VSS.n104 513.399
R499 VSS.n177 VSS.n176 513.399
R500 VSS.n177 VSS.n103 513.399
R501 VSS.n181 VSS.n180 513.399
R502 VSS.n182 VSS.n181 513.399
R503 VSS.n182 VSS.n100 513.399
R504 VSS.n186 VSS.n185 513.399
R505 VSS.n187 VSS.n186 513.399
R506 VSS.n191 VSS.n98 513.399
R507 VSS.n192 VSS.n191 513.399
R508 VSS.n193 VSS.n192 513.399
R509 VSS.n196 VSS.n96 513.399
R510 VSS.n197 VSS.n196 513.399
R511 VSS.n198 VSS.n94 513.399
R512 VSS.n202 VSS.n94 513.399
R513 VSS.n203 VSS.n202 513.399
R514 VSS.n204 VSS.n92 513.399
R515 VSS.n207 VSS.n92 513.399
R516 VSS.n208 VSS.n207 513.399
R517 VSS.n209 VSS.n88 513.399
R518 VSS.n212 VSS.n88 513.399
R519 VSS.n214 VSS.n213 513.399
R520 VSS.n214 VSS.n87 513.399
R521 VSS.n218 VSS.n217 513.399
R522 VSS.n219 VSS.n218 513.399
R523 VSS.n219 VSS.n84 513.399
R524 VSS.n209 VSS.t29 495.063
R525 VSS.n107 VSS.t18 490.481
R526 VSS.n167 VSS.t2 462.976
R527 VSS.n158 VSS.t20 458.392
R528 VSS.n137 VSS.t22 453.808
R529 VSS.t35 VSS.n96 421.721
R530 VSS.n103 VSS.t16 417.137
R531 VSS.t28 VSS.n152 412.553
R532 VSS.n121 VSS.t12 398.801
R533 VSS.n127 VSS.t26 380.466
R534 VSS.n185 VSS.t15 366.714
R535 VSS.t0 VSS.n197 362.13
R536 VSS.n150 VSS.t4 343.795
R537 VSS.n213 VSS.t30 343.795
R538 VSS.n187 VSS.t8 339.211
R539 VSS.n87 VSS.t6 325.459
R540 VSS.t34 VSS.n161 320.875
R541 VSS.n176 VSS.t14 293.372
R542 VSS.n128 VSS.t10 288.788
R543 VSS.t32 VSS.n203 288.788
R544 VSS.n141 VSS.t24 270.452
R545 VSS.n122 VSS.t24 242.948
R546 VSS.n228 VSS.t10 224.613
R547 VSS.n204 VSS.t32 224.613
R548 VSS.t14 VSS.n175 220.029
R549 VSS.n162 VSS.t34 192.525
R550 VSS.n217 VSS.t6 187.941
R551 VSS.t8 VSS.n98 174.19
R552 VSS.t4 VSS.n149 169.606
R553 VSS.t30 VSS.n212 169.606
R554 VSS.n198 VSS.t0 151.269
R555 VSS.n100 VSS.t15 146.685
R556 VSS.n132 VSS.t26 132.935
R557 VSS.n145 VSS.t12 114.599
R558 VSS.n153 VSS.t28 100.847
R559 VSS.n180 VSS.t16 96.2628
R560 VSS.n193 VSS.t35 91.6789
R561 VSS.t22 VSS.n136 59.5915
R562 VSS.t20 VSS.n157 55.0075
R563 VSS.t2 VSS.n166 50.4236
R564 VSS.n220 VSS.n50 6.5635
R565 VSS.n206 VSS.n91 23.3338
R566 VSS.n210 VSS.n49 6.5635
R567 VSS.n210 VSS.n90 23.3338
R568 VSS.n201 VSS.n76 23.3338
R569 VSS.n194 VSS.n97 23.3338
R570 VSS.n47 VSS.n46 6.5635
R571 VSS.n195 VSS.n46 23.3338
R572 VSS.n48 VSS.n71 6.5635
R573 VSS.n183 VSS.n43 23.3338
R574 VSS.n184 VSS.n43 23.3338
R575 VSS.n45 VSS.n44 6.5635
R576 VSS.n188 VSS.n44 23.3338
R577 VSS.n174 VSS.n68 23.3338
R578 VSS.n41 VSS.n102 6.5635
R579 VSS.n178 VSS.n102 23.3338
R580 VSS.n42 VSS.n67 6.5635
R581 VSS.n169 VSS.n106 23.3338
R582 VSS.n160 VSS.n72 23.3338
R583 VSS.n40 VSS.n111 6.5635
R584 VSS.n164 VSS.n111 23.3338
R585 VSS.n164 VSS.n110 23.3338
R586 VSS.n37 VSS.n115 6.5635
R587 VSS.n155 VSS.n115 23.3338
R588 VSS.n39 VSS.n38 6.5635
R589 VSS.n139 VSS.n81 23.3338
R590 VSS.n229 VSS.n83 23.3338
R591 VSS.n215 VSS.n73 23.251
R592 VSS.n151 VSS.n82 23.251
R593 VSS.n211 VSS.n52 6.53281
R594 VSS.n148 VSS.n63 23.1406
R595 VSS.n171 VSS.t18 22.9201
R596 VSS.n130 VSS.n54 6.49747
R597 VSS.n143 VSS.n57 6.47968
R598 VSS.n206 VSS.n33 6.43489
R599 VSS.n135 VSS.n61 22.4779
R600 VSS.n156 VSS.n38 22.4503
R601 VSS.n60 VSS.n110 6.41685
R602 VSS.n220 VSS.n80 22.3122
R603 VSS.n35 VSS.n97 6.38508
R604 VSS.n201 VSS.n58 6.36225
R605 VSS.n65 VSS.n106 6.34389
R606 VSS.n62 VSS.n61 6.34389
R607 VSS.n64 VSS.n63 6.32546
R608 VSS.n183 VSS.n66 6.30695
R609 VSS.n179 VSS.n67 21.5392
R610 VSS.n144 VSS.n69 21.4287
R611 VSS.n36 VSS.n68 6.23211
R612 VSS.n131 VSS.n70 21.3183
R613 VSS.n199 VSS.n71 21.2078
R614 VSS.n189 VSS.n51 6.18944
R615 VSS.n216 VSS.n55 6.17512
R616 VSS.n169 VSS.n77 20.8765
R617 VSS.n159 VSS.n53 6.15116
R618 VSS.n56 VSS.n21 6.14636
R619 VSS.n205 VSS.n59 6.13672
R620 VSS.n140 VSS.n34 6.08825
R621 VSS.n229 VSS.n26 20.3795
R622 VSS.n211 VSS.n3 19.88
R623 VSS.n148 VSS.n2 19.88
R624 VSS.n130 VSS.n28 18.4342
R625 VSS.t29 VSS.n208 18.3362
R626 VSS.n143 VSS.n20 17.7113
R627 VSS.n10 VSS.n9 15.9041
R628 VSS.n32 VSS.n83 15.8338
R629 VSS.n221 VSS.n85 15.8338
R630 VSS.n135 VSS.n23 6.12927
R631 VSS.n156 VSS.n16 6.08692
R632 VSS VSS.n225 15.2537
R633 VSS.n224 VSS.n6 15.2537
R634 VSS.n165 VSS.n78 15.1812
R635 VSS.n229 VSS.n228 15.0005
R636 VSS VSS.n229 15.0005
R637 VSS.n227 VSS.n83 15.0005
R638 VSS.n83 VSS 15.0005
R639 VSS.n130 VSS.n129 15.0005
R640 VSS VSS.n54 4.25277
R641 VSS.n128 VSS.n26 15.0005
R642 VSS.n27 VSS 4.54513
R643 VSS.n127 VSS.n70 15.0005
R644 VSS.n54 VSS.n70 6.49747
R645 VSS.n134 VSS.n133 15.0005
R646 VSS.n62 VSS.n134 6.34389
R647 VSS.n132 VSS.n131 15.0005
R648 VSS.n24 VSS 3.69536
R649 VSS.n61 VSS.n123 15.0005
R650 VSS VSS.n62 4.32955
R651 VSS.n137 VSS.n21 15.0005
R652 VSS VSS.n56 4.42832
R653 VSS.n136 VSS.n135 15.0005
R654 VSS.n23 VSS 2.95824
R655 VSS.n122 VSS.n81 15.0005
R656 VSS.n34 VSS.n81 6.08825
R657 VSS.n139 VSS.n138 15.0005
R658 VSS.n56 VSS.n139 6.14636
R659 VSS.n143 VSS.n142 15.0005
R660 VSS VSS.n57 4.26166
R661 VSS.n141 VSS.n140 15.0005
R662 VSS.n34 VSS 4.45738
R663 VSS.n121 VSS.n69 15.0005
R664 VSS.n57 VSS.n69 6.47968
R665 VSS.n147 VSS.n146 15.0005
R666 VSS.n64 VSS.n147 6.32546
R667 VSS.n145 VSS.n144 15.0005
R668 VSS.n18 VSS 3.6097
R669 VSS.n63 VSS.n118 15.0005
R670 VSS VSS.n64 4.33877
R671 VSS.n2 VSS.n150 15.0005
R672 VSS VSS.n1 1.78457
R673 VSS.n149 VSS.n148 15.0005
R674 VSS.n148 VSS 15.0005
R675 VSS.n38 VSS.n114 15.0005
R676 VSS.n5 VSS.n39 4.21975
R677 VSS.n155 VSS.n154 15.0005
R678 VSS.n39 VSS.n155 6.5635
R679 VSS.n153 VSS.n115 15.0005
R680 VSS.n37 VSS 4.21975
R681 VSS.n152 VSS.n151 15.0005
R682 VSS.n151 VSS.n37 6.5635
R683 VSS.n82 VSS.n116 15.0005
R684 VSS.n159 VSS.n158 15.0005
R685 VSS.n5 VSS.n53 4.42592
R686 VSS.n157 VSS.n156 15.0005
R687 VSS.n16 VSS.n5 2.97236
R688 VSS.n110 VSS.n108 15.0005
R689 VSS.n5 VSS.n60 4.29308
R690 VSS.n164 VSS.n163 15.0005
R691 VSS.n5 VSS.n164 15.0005
R692 VSS.n162 VSS.n111 15.0005
R693 VSS.n40 VSS.n5 4.21975
R694 VSS.n161 VSS.n160 15.0005
R695 VSS.n160 VSS.n40 6.5635
R696 VSS.n72 VSS.n112 15.0005
R697 VSS.n53 VSS.n72 6.15116
R698 VSS.n167 VSS.n77 15.0005
R699 VSS.n5 VSS.n79 4.08297
R700 VSS.n166 VSS.n165 15.0005
R701 VSS.n165 VSS.n60 6.41685
R702 VSS.n107 VSS.n106 15.0005
R703 VSS.n5 VSS.n65 4.32955
R704 VSS.n169 VSS.n168 15.0005
R705 VSS.n5 VSS.n169 15.0005
R706 VSS.n173 VSS.n172 15.0005
R707 VSS.n36 VSS.n173 6.23211
R708 VSS.n171 VSS.n170 15.0005
R709 VSS.n170 VSS.n65 6.34389
R710 VSS.n103 VSS.n67 15.0005
R711 VSS.n5 VSS.n42 4.21975
R712 VSS.n178 VSS.n177 15.0005
R713 VSS.n42 VSS.n178 6.5635
R714 VSS.n176 VSS.n102 15.0005
R715 VSS.n41 VSS.n5 4.21975
R716 VSS.n175 VSS.n174 15.0005
R717 VSS.n174 VSS.n41 6.5635
R718 VSS.n68 VSS.n104 15.0005
R719 VSS.n5 VSS.n36 4.38545
R720 VSS.n181 VSS.n12 15.0005
R721 VSS.n66 VSS.n12 6.30695
R722 VSS.n180 VSS.n179 15.0005
R723 VSS.n14 VSS.n5 3.52791
R724 VSS.n188 VSS.n187 15.0005
R725 VSS.n188 VSS.n51 6.18944
R726 VSS.n186 VSS.n44 15.0005
R727 VSS.n0 VSS.n45 4.21975
R728 VSS.n185 VSS.n184 15.0005
R729 VSS.n184 VSS.n45 6.5635
R730 VSS.n100 VSS.n43 15.0005
R731 VSS.n0 VSS.n43 15.0005
R732 VSS.n183 VSS.n182 15.0005
R733 VSS.n0 VSS.n66 4.34803
R734 VSS.n191 VSS.n190 15.0005
R735 VSS.n190 VSS.n35 6.38508
R736 VSS.n189 VSS.n98 15.0005
R737 VSS.n0 VSS.n51 4.40678
R738 VSS.n197 VSS.n71 15.0005
R739 VSS.n0 VSS.n48 4.21975
R740 VSS.n196 VSS.n195 15.0005
R741 VSS.n195 VSS.n48 6.5635
R742 VSS.n46 VSS.n96 15.0005
R743 VSS.n0 VSS.n47 4.21975
R744 VSS.n194 VSS.n193 15.0005
R745 VSS.n47 VSS.n194 6.5635
R746 VSS.n192 VSS.n97 15.0005
R747 VSS.n35 VSS.n0 4.30896
R748 VSS.n74 VSS.n94 15.0005
R749 VSS.n58 VSS.n74 6.36225
R750 VSS.n199 VSS.n198 15.0005
R751 VSS.n75 VSS.n0 3.78519
R752 VSS.n203 VSS.n76 15.0005
R753 VSS.n59 VSS.n76 6.13672
R754 VSS.n202 VSS.n201 15.0005
R755 VSS.n58 VSS.n0 4.32038
R756 VSS.n9 VSS.n92 15.0005
R757 VSS.n33 VSS.n9 6.43489
R758 VSS.n205 VSS.n204 15.0005
R759 VSS.n59 VSS.n0 4.43314
R760 VSS.n90 VSS.n88 15.0005
R761 VSS.n52 VSS.n90 6.53281
R762 VSS.n210 VSS.n209 15.0005
R763 VSS.n0 VSS.n49 4.21975
R764 VSS.n208 VSS.n91 15.0005
R765 VSS.n91 VSS.n49 6.5635
R766 VSS.n207 VSS.n206 15.0005
R767 VSS.n33 VSS.n0 4.28405
R768 VSS.n213 VSS.n3 15.0005
R769 VSS.n0 VSS.n4 1.78457
R770 VSS.n212 VSS.n211 15.0005
R771 VSS.n52 VSS.n0 4.23509
R772 VSS.n87 VSS.n73 15.0005
R773 VSS.n55 VSS.n73 6.17512
R774 VSS.n215 VSS.n214 15.0005
R775 VSS.n218 VSS.n80 15.0005
R776 VSS.n0 VSS.n8 3.04501
R777 VSS.n217 VSS.n216 15.0005
R778 VSS.n55 VSS.n0 4.41394
R779 VSS.n85 VSS.n84 15.0005
R780 VSS.n50 VSS.n85 6.5635
R781 VSS.n220 VSS.n219 15.0005
R782 VSS.n0 VSS.n50 4.21975
R783 VSS.n31 VSS.n6 4.21975
R784 VSS.n222 VSS.n31 13.1265
R785 VSS.n221 VSS.n6 15.0005
R786 VSS VSS.n32 15.0005
R787 VSS VSS.n30 4.21975
R788 VSS.n8 VSS.n80 5.86897
R789 VSS.n190 VSS.n11 13.9162
R790 VSS.n200 VSS.n74 13.0125
R791 VSS.n170 VSS.n15 12.2897
R792 VSS.n134 VSS.n25 12.2897
R793 VSS.n147 VSS.n19 11.5668
R794 VSS.n200 VSS.t1 10.9505
R795 VSS.n78 VSS.t3 10.9505
R796 VSS.n13 VSS.n12 10.8439
R797 VSS.n7 VSS.t7 10.5005
R798 VSS.n3 VSS.t31 10.5005
R799 VSS.n10 VSS.t33 10.5005
R800 VSS.n11 VSS.t9 10.5005
R801 VSS.n13 VSS.t17 10.5005
R802 VSS.n15 VSS.t19 10.5005
R803 VSS.n17 VSS.t21 10.5005
R804 VSS.n2 VSS.t5 10.5005
R805 VSS.n19 VSS.t13 10.5005
R806 VSS.n20 VSS.t25 10.5005
R807 VSS.n22 VSS.t23 10.5005
R808 VSS.n25 VSS.t27 10.5005
R809 VSS.n28 VSS.t11 10.5005
R810 VSS.n179 VSS.n14 4.42026
R811 VSS.n144 VSS.n18 4.17491
R812 VSS.n173 VSS.n15 7.95231
R813 VSS.n131 VSS.n24 3.91791
R814 VSS.n28 VSS.n27 0.684809
R815 VSS.n25 VSS.n24 1.95946
R816 VSS.n23 VSS.n22 3.06513
R817 VSS.n20 VSS 7.5005
R818 VSS.n19 VSS.n18 2.08796
R819 VSS.n2 VSS.n1 2.73081
R820 VSS.n17 VSS.n16 3.04396
R821 VSS.n79 VSS.n78 1.37805
R822 VSS.n15 VSS.n5 7.5005
R823 VSS.n14 VSS.n13 2.21063
R824 VSS.n0 VSS.n11 7.5005
R825 VSS.n75 VSS.n200 1.82471
R826 VSS.n0 VSS.n10 7.5005
R827 VSS.n4 VSS.n3 2.73081
R828 VSS.n8 VSS.n7 2.93499
R829 VSS.n75 VSS.n199 3.64842
R830 VSS.n0 VSS 7.01357
R831 VSS.n0 VSS 6.6929
R832 VSS.n7 VSS.n86 6.6005
R833 VSS.n3 VSS.n89 6.6005
R834 VSS.n10 VSS.n93 6.6005
R835 VSS.n200 VSS.n95 6.6005
R836 VSS.n11 VSS.n99 6.6005
R837 VSS.n78 VSS.n109 6.6005
R838 VSS.n17 VSS.n113 6.6005
R839 VSS.n2 VSS.n117 6.6005
R840 VSS.n20 VSS.n120 6.6005
R841 VSS.n22 VSS.n124 6.6005
R842 VSS.n28 VSS.n126 6.6005
R843 VSS.n225 VSS.n29 6.5635
R844 VSS.n224 VSS.n223 6.5635
R845 VSS.n226 VSS.n32 6.5635
R846 VSS.n226 VSS.n30 13.1265
R847 VSS.n30 VSS.n29 13.1265
R848 VSS.n222 VSS.n221 6.5635
R849 VSS.n223 VSS.n31 13.1265
R850 VSS.n25 VSS.n125 7.0505
R851 VSS.n19 VSS.n119 7.0505
R852 VSS.n15 VSS.n105 7.0505
R853 VSS.n13 VSS.n101 7.0505
R854 VSS.n215 VSS.n4 7.67488
R855 VSS.n1 VSS.n82 7.67488
R856 VSS.n189 VSS.n11 6.7758
R857 VSS.n216 VSS.n7 6.23363
R858 VSS.n0 VSS 6.03597
R859 VSS.n0 VSS 5.6659
R860 VSS.n159 VSS.n17 5.33002
R861 VSS.n22 VSS.n21 5.1493
R862 VSS.n79 VSS.n77 2.7551
R863 VSS.n0 VSS 4.97777
R864 VSS.n10 VSS.n205 4.78785
R865 VSS.n0 VSS 4.62468
R866 VSS.n0 VSS 4.40728
R867 VSS.n0 VSS 4.31303
R868 VSS.n223 VSS.n84 4.21975
R869 VSS.n222 VSS.n84 4.21975
R870 VSS.n227 VSS.n226 4.21975
R871 VSS.n227 VSS.n29 4.21975
R872 VSS.n0 VSS 3.9619
R873 VSS.n0 VSS 3.70807
R874 VSS.n5 VSS 3.64743
R875 VSS.n5 VSS 3.27737
R876 VSS.n0 VSS 3.24448
R877 VSS.n140 VSS.n20 2.98062
R878 VSS.n5 VSS 2.79381
R879 VSS.n5 VSS 2.59443
R880 VSS.n5 VSS 2.34256
R881 VSS.n6 VSS.n0 2.12247
R882 VSS.n27 VSS.n26 1.36862
R883 VSS.n5 VSS 2.08873
R884 VSS.n5 VSS 1.8902
R885 VSS.n5 VSS 1.62866
R886 VSS.n5 VSS.n0 1.42965
R887 a_6694_987.t2 a_6694_987.n1 11.571
R888 a_6694_987.n1 a_6694_987.t1 11.5552
R889 a_6694_987.n1 a_6694_987.n0 7.5005
R890 a_6694_987.n0 a_6694_987.t0 3.03552
R891 a_6694_987.n0 a_6694_987.t3 3.03552
R892 a_5474_987.n0 a_5474_987.t1 11.5552
R893 a_5474_987.n1 a_5474_987.t2 11.4082
R894 a_5474_987.t4 a_5474_987.n1 10.687
R895 a_5474_987.n1 a_5474_987.t3 10.6847
R896 a_5474_987.n0 a_5474_987.n2 7.5005
R897 a_5474_987.n2 a_5474_987.t0 3.03552
R898 a_5474_987.n2 a_5474_987.t5 3.03552
R899 a_5474_987.n1 a_5474_987.n0 1.18293
R900 a_4706_987.n0 a_4706_987.t0 11.571
R901 a_4706_987.n0 a_4706_987.t2 11.5552
R902 a_4706_987.n1 a_4706_987.n0 7.5005
R903 a_4706_987.n1 a_4706_987.t3 3.03552
R904 a_4706_987.t1 a_4706_987.n1 3.03552
R905 a_3938_987.n0 a_3938_987.t0 11.571
R906 a_3938_987.n0 a_3938_987.t3 11.5552
R907 a_3938_987.n1 a_3938_987.n0 7.5005
R908 a_3938_987.n1 a_3938_987.t2 3.03552
R909 a_3938_987.t1 a_3938_987.n1 3.03552
R910 a_2717_987.n0 a_2717_987.t1 11.5552
R911 a_2717_987.n1 a_2717_987.t3 11.4082
R912 a_2717_987.t4 a_2717_987.n1 10.687
R913 a_2717_987.n1 a_2717_987.t2 10.6847
R914 a_2717_987.n0 a_2717_987.n2 7.5005
R915 a_2717_987.n2 a_2717_987.t0 3.03552
R916 a_2717_987.n2 a_2717_987.t5 3.03552
R917 a_2717_987.n1 a_2717_987.n0 1.1852
R918 a_1948_987.n0 a_1948_987.t0 11.571
R919 a_1948_987.n0 a_1948_987.t2 11.5552
R920 a_1948_987.n1 a_1948_987.n0 7.5005
R921 a_1948_987.n1 a_1948_987.t3 3.03552
R922 a_1948_987.t1 a_1948_987.n1 3.03552
R923 in2.t2 in2.n21 229.018
R924 in2.n12 in2.n8 210
R925 in2.n23 in2.n22 210
R926 in2.n15 in2.n5 202.5
R927 in2.t2 in2.n3 4.02627
R928 in2.n8 in2.n5 112.501
R929 in2.n16 in2.n15 112.501
R930 in2.n22 in2.n19 112.501
R931 in2.n27 in2.t7 77.8576
R932 in2.n27 in2.t8 39.6434
R933 in2.n2 in2.n25 10.8079
R934 in2.n9 in2.n7 35.0626
R935 in2.n12 in2.n11 31.9491
R936 in2.n25 in2.n23 31.9491
R937 in2.n0 in2.n29 31.5253
R938 in2.n18 in2.n4 31.1831
R939 in2.n18 in2.n17 30.5821
R940 in2.n13 in2.n12 22.7684
R941 in2.n23 in2.n21 22.7684
R942 in2.n16 in2.n14 22.5005
R943 in2 in2.n18 18.1807
R944 in2.n14 in2.n7 17.1346
R945 in2.n17 in2.t5 15.2591
R946 in2.n26 in2.t2 15.2591
R947 in2.n29 in2.n27 15.1346
R948 in2.n0 in2.n26 15.0005
R949 in2.n29 in2.n28 15.0005
R950 in2.n14 in2.n13 11.777
R951 in2.n9 in2.n1 10.8735
R952 in2.n13 in2.n6 7.5005
R953 in2.n15 in2.n6 7.5005
R954 in2.t5 in2.n16 7.5005
R955 in2.n21 in2.n20 7.5005
R956 in2.n19 in2.n3 209.323
R957 in2.t5 in2.n1 0.489634
R958 in2.t2 in2.n2 0.379787
R959 in2 in2.t6 12.9092
R960 in2.t5 in2.n7 4.82859
R961 in2.n3 in2.n20 0.252579
R962 in2.n8 in2.n6 4.16717
R963 in2.n22 in2.n20 4.16717
R964 in2.n17 in2.n5 3.87981
R965 in2.n26 in2.n19 3.87981
R966 in2.n1 in2.n5 9.25828
R967 in2.n2 in2.n19 9.36437
R968 in2.t5 in2.n6 4.42579
R969 in2.n4 in2.t0 3.03552
R970 in2.n4 in2.t1 3.03552
R971 in2.n28 in2.t3 3.03552
R972 in2.n28 in2.t4 3.03552
R973 in2.n11 in2.n10 2.72827
R974 in2.n25 in2.n24 2.72827
R975 in2.n11 in2.n9 2.38736
R976 in2 in2.n0 1.48667
R977 R.n7 R.n6 307.5
R978 R.n3 R.t5 82.5005
R979 R.n12 R.t7 82.5005
R980 R.n9 R.n8 75.4554
R981 R.n3 R.t6 39.6434
R982 R.n12 R.t8 39.6434
R983 R.n0 R.n16 5.33524
R984 R.n11 R.n3 36.6121
R985 R.n13 R.n12 36.541
R986 R R.n17 30.6726
R987 R.n11 R.n10 24.7039
R988 R R.n2 23.6392
R989 R.n14 R.n11 21.3262
R990 R.n1 R.n0 6.69255
R991 R.n6 R.n5 20.7085
R992 R.n10 R.n4 16.788
R993 R.n14 R.n13 15.0005
R994 R.n9 R.n5 12.0226
R995 R.n13 R.t4 36.6343
R996 R R.n14 19.3468
R997 R.n8 R.n6 8.78735
R998 R.n0 R.n15 1.09116
R999 R.n10 R.n9 5.88285
R1000 R.t3 R.n7 4.98488
R1001 R.t2 R.n15 4.13843
R1002 R.n17 R.n15 4.13843
R1003 R.n5 R.n4 3.26079
R1004 R.n2 R.t0 3.03552
R1005 R.n2 R.t1 3.03552
R1006 R.n7 R.n4 2.65923
R1007 R.n8 R.t3 2.28378
R1008 R.n17 R.n1 4.29424
R1009 R.n1 R.t2 2.26793
R1010 in1.t5 in1.n23 229.018
R1011 in1.t0 in1.n1 4.01391
R1012 in1.t0 in1.n0 0.361235
R1013 in1.n25 in1.n24 210
R1014 in1.n8 in1.n7 202.5
R1015 in1.t5 in1.n5 4.02627
R1016 in1.n11 in1.n8 112.501
R1017 in1.n34 in1.n32 112.501
R1018 in1.n24 in1.n21 112.501
R1019 in1.n36 in1.n32 97.5005
R1020 in1.n18 in1.t7 82.5005
R1021 in1.n33 in1.t6 58.9602
R1022 in1.n20 in1.n18 55.8772
R1023 in1.n14 in1.n13 47.6267
R1024 in1.n18 in1.t8 39.6434
R1025 in1.n4 in1.n27 10.8079
R1026 in1.n12 in1.n3 34.7947
R1027 in1.n27 in1.n25 31.9491
R1028 in1.n2 in1.n20 31.6842
R1029 in1.n17 in1.n6 31.1491
R1030 in1.n17 in1.n16 30.4718
R1031 in1.n25 in1.n23 22.7684
R1032 in1.n11 in1.n9 22.5005
R1033 in1.n33 in1.n31 20.455
R1034 in1 in1.n17 18.288
R1035 in1.n32 in1.n30 17.2505
R1036 in1.n3 in1.n9 17.1346
R1037 in1.n28 in1.t5 15.2591
R1038 in1.n20 in1.n19 15.0005
R1039 in1.n2 in1.n28 15.0005
R1040 in1.n38 in1.n30 14.0005
R1041 in1.n14 in1.n9 11.777
R1042 in1.n34 in1.n33 11.5184
R1043 in1.n38 in1.n37 11.4158
R1044 in1.t6 in1.n29 9.38071
R1045 in1.n37 in1.n31 9.063
R1046 in1.n30 in1.n29 8.03621
R1047 in1.n12 in1.n0 11.6304
R1048 in1.n15 in1.n14 7.5005
R1049 in1.n15 in1.n8 7.5005
R1050 in1.t0 in1.n11 7.5005
R1051 in1.n35 in1.n31 7.5005
R1052 in1.n37 in1.n36 7.5005
R1053 in1.n23 in1.n22 7.5005
R1054 in1.n21 in1.n5 209.323
R1055 in1.n16 in1.t0 6.98326
R1056 in1.t5 in1.n4 0.379787
R1057 in1 in1.n39 5.0005
R1058 in1.t0 in1.n3 4.82859
R1059 in1.n39 in1.n29 4.6505
R1060 in1.n5 in1.n22 0.252579
R1061 in1.n0 in1.n7 9.20397
R1062 in1.n15 in1.n1 0.0778758
R1063 in1.n7 in1.n1 116.513
R1064 in1.n24 in1.n22 4.16717
R1065 in1.n35 in1.n34 4.01836
R1066 in1.n13 in1.n12 3.95439
R1067 in1.n16 in1.n7 3.87981
R1068 in1.n28 in1.n21 3.87981
R1069 in1.n4 in1.n21 9.36437
R1070 in1.n36 in1.n35 3.7505
R1071 in1.n19 in1.t1 3.03552
R1072 in1.n19 in1.t2 3.03552
R1073 in1.n6 in1.t3 3.03552
R1074 in1.n6 in1.t4 3.03552
R1075 in1.n27 in1.n26 2.72827
R1076 in1.n39 in1.n38 2.1005
R1077 in1 in1.n2 1.53163
R1078 in1.n13 in1.n10 1.40041
C0 CLKb VDD 1.31034f
C1 a_4039_203r# out1 0.21267f
C2 in2 VDD 0.56088f
C3 D a_2065_203r# 0.10735f
C4 out2 a_6795_203r# 0.23544f
C5 CLKN RN 0.18897f
C6 CLK CLKN 0.29038f
C7 in1 out1 1.00707f
C8 CLKb RN 0.10733f
C9 in1 CLKN 0.56278f
C10 CLKb in1 0.84248f
C11 VDD RN 0.4489f
C12 a_4807_203r# out1 0.10484f
C13 CLK VDD 0.5524f
C14 in1 VDD 0.52575f
C15 SNb a_921_203r# 0.33112f
C16 QN Q 0.31543f
C17 SNb R 2.56792f
C18 Q VDD 0.32451f
C19 D R 0.1752f
C20 SN a_921_203r# 0.26968f
C21 CLKN a_921_203r# 0.14227f
C22 out2 R 0.51911f
C23 SNb out1 0.11707f
C24 SNb CLKN 1.10619f
C25 VDD a_921_203r# 0.56411f
C26 CLKb SNb 2.343f
C27 in2 SNb 0.25688f
C28 R out1 0.51982f
C29 R CLKN 1.97051f
C30 SNb VDD 1.041f
C31 D CLKN 0.22955f
C32 in2 a_5574_203r# 0.16682f
C33 CLKb R 1.049f
C34 CLKb D 0.1817f
C35 in2 R 0.24944f
C36 out2 QN 0.34979f
C37 R VDD 1.26942f
C38 SNb RN 0.30052f
C39 D VDD 0.35858f
C40 out2 CLKN 0.50956f
C41 in1 SNb 0.27627f
C42 in1 a_2824_203r# 0.1706f
C43 in2 out2 0.97372f
C44 R RN 0.19832f
C45 SN CLKN 0.22893f
C46 CLKN out1 0.52264f
C47 out2 VDD 0.97621f
C48 CLKb SN 0.34074f
C49 in1 R 0.28719f
C50 CLKb out1 0.35292f
C51 CLKb CLKN 1.14985f
C52 QN VDD 0.73132f
C53 in2 CLKN 0.56927f
C54 SN VDD 0.60922f
C55 in2 CLKb 0.73484f
C56 VDD out1 0.74449f
C57 CLKN VDD 1.75373f
C58 Q VSS 0.52936f
C59 QN VSS 1.09107f
C60 D VSS 0.93761f
C61 RN VSS 0.93363f
C62 SN VSS 0.8918f
C63 CLK VSS 0.98617f
C64 VDD VSS 22.22284f
C65 a_5574_203r# VSS 0.28609f
C66 a_4807_203r# VSS 0.35838f
C67 a_4039_203r# VSS 1.33586f
C68 a_2824_203r# VSS 0.77739f
C69 a_2065_203r# VSS 1.12259f
C70 out2 VSS 0.10564f
C71 in2 VSS 1.53861f
C72 R VSS 1.6973f
C73 SNb VSS 0.18533f
C74 in1 VSS 1.33471f
C75 in1.t0 VSS 0.77863f
C76 in1.n2 VSS 0.3672f
C77 in1.t5 VSS 0.99023f
C78 in1.n6 VSS 0.14201f
C79 in1.n17 VSS 0.52889f
C80 in1.n18 VSS 0.14441f
C81 in1.n20 VSS 0.39983f
C82 in1.n29 VSS 0.1045f
C83 in1.n33 VSS 0.151f
C84 R.n1 VSS 0.16959f
C85 R.t1 VSS 0.14931f
C86 R.t0 VSS 0.13225f
C87 R.n2 VSS 0.36969f
C88 R.n3 VSS 0.24962f
C89 R.n8 VSS 0.29345f
C90 R.n9 VSS 0.42071f
C91 R.n10 VSS 0.27474f
C92 R.n11 VSS 0.72935f
C93 R.n12 VSS 0.23522f
C94 R.n13 VSS 0.57116f
C95 R.n14 VSS 2.1736f
C96 R.t2 VSS 0.24218f
C97 R.n16 VSS 0.2963f
C98 R.n17 VSS 0.13214f
C99 in2.n0 VSS 0.32958f
C100 in2.t2 VSS 0.12466f
C101 in2.n4 VSS 0.14903f
C102 in2.n18 VSS 0.51932f
C103 in2.n27 VSS 0.15439f
C104 in2.t4 VSS 0.11692f
C105 in2.n29 VSS 0.48517f
C106 a_1948_987.t2 VSS 0.14178f
C107 a_1948_987.t0 VSS 0.19187f
C108 a_1948_987.n0 VSS 0.44063f
C109 a_1948_987.t1 VSS 0.10409f
C110 a_2717_987.n0 VSS 0.27715f
C111 a_2717_987.n1 VSS 0.46171f
C112 a_2717_987.t1 VSS 0.24908f
C113 a_2717_987.t0 VSS 0.12756f
C114 a_2717_987.t2 VSS 0.19271f
C115 a_2717_987.t3 VSS 0.18279f
C116 a_2717_987.t4 VSS 0.12403f
C117 a_3938_987.t3 VSS 0.14491f
C118 a_3938_987.t0 VSS 0.14522f
C119 a_3938_987.n0 VSS 0.45035f
C120 a_4706_987.t2 VSS 0.21623f
C121 a_4706_987.t0 VSS 0.51125f
C122 a_4706_987.n0 VSS 0.45455f
C123 a_5474_987.n0 VSS 0.27108f
C124 a_5474_987.n1 VSS 0.45128f
C125 a_5474_987.t1 VSS 0.2461f
C126 a_5474_987.t0 VSS 0.12657f
C127 a_5474_987.t3 VSS 0.18743f
C128 a_5474_987.t2 VSS 0.17878f
C129 a_5474_987.t4 VSS 0.25677f
C130 a_6694_987.t1 VSS 0.14635f
C131 a_6694_987.n1 VSS 0.45483f
C132 a_6694_987.t2 VSS 0.20335f
C133 VSS.t7 VSS 0.13847f
C134 VSS.t31 VSS 0.54466f
C135 VSS.t17 VSS 0.30288f
C136 VSS.t19 VSS 0.5439f
C137 VSS.t3 VSS 0.52377f
C138 VSS.t21 VSS 0.10778f
C139 VSS.t5 VSS 0.20081f
C140 VSS.t13 VSS 0.19659f
C141 VSS.t25 VSS 0.27091f
C142 VSS.t23 VSS 0.32162f
C143 VSS.t11 VSS 0.13995f
C144 VSS.t9 VSS 0.23076f
C145 VDD.n0 VSS 0.55244f
C146 VDD.n1 VSS 0.35406f
C147 VDD.n4 VSS 0.20252f
C148 VDD.n5 VSS 0.19796f
C149 VDD.n7 VSS 0.29237f
C150 VDD.n56 VSS 0.14001f
C151 VDD.n69 VSS 0.12626f
C152 VDD.t69 VSS 0.14568f
C153 VDD.n72 VSS 0.1f
C154 VDD.n73 VSS 0.11625f
C155 VDD.n77 VSS 0.11625f
C156 VDD.t37 VSS 0.37491f
C157 VDD.n82 VSS 0.1f
C158 VDD.n85 VSS 0.1f
C159 VDD.n92 VSS 0.14001f
C160 VDD.n95 VSS 0.14001f
C161 VDD.n104 VSS 0.1f
C162 VDD.t47 VSS 0.19555f
C163 VDD.n110 VSS 0.12f
C164 VDD.n113 VSS 0.1f
C165 VDD.n120 VSS 0.13001f
C166 VDD.n125 VSS 0.1f
C167 VDD.t46 VSS 0.14001f
C168 VDD.n128 VSS 0.1f
C169 VDD.n129 VSS 0.1f
C170 VDD.n132 VSS 0.14001f
C171 VDD.n133 VSS 0.1f
C172 VDD.n134 VSS 0.1f
C173 VDD.n138 VSS 0.1f
C174 VDD.n143 VSS 0.1f
C175 VDD.n148 VSS 0.1f
C176 VDD.n152 VSS 0.1f
C177 VDD.n154 VSS 0.14001f
C178 VDD.n157 VSS 0.1f
C179 VDD.n162 VSS 0.10625f
C180 VDD.n163 VSS 0.14001f
C181 VDD.n167 VSS 0.1f
C182 VDD.n172 VSS 0.13375f
C183 VDD.n177 VSS 0.13626f
C184 VDD.n184 VSS 0.12375f
C185 VDD.n189 VSS 0.1f
C186 VDD.n193 VSS 0.13375f
C187 VDD.n194 VSS 0.11625f
C188 VDD.n198 VSS 0.1f
C189 VDD.n199 VSS 0.1f
C190 VDD.n203 VSS 0.26251f
C191 VDD.n204 VSS 0.28823f
C192 VDD.n205 VSS 0.28823f
C193 VDD.n206 VSS 0.18251f
C194 VDD.n207 VSS 0.13001f
C195 SN.n0 VSS 0.14877f
C196 RN.n0 VSS 0.22599f
C197 D.n0 VSS 0.26899f
C198 QN.t0 VSS 0.55564f
C199 QN.n6 VSS 0.1152f
C200 Q.t2 VSS 0.14921f
.ends
