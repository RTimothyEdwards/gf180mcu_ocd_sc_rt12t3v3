* NGSPICE file created from gf180mcu_ocd_sc_rt12t3v3__dlat_1.ext - technology: gf180mcuD

.subckt gf180mcu_ocd_sc_rt12t3v3__dlat_1 D CLK Q VDD VSS
X0 a_828_987.t2 CLKN in2.t2 VDD.t18 pfet_03v3 ad=0.5654p pd=3.45u as=0.3341p ps=1.805u w=1.285u l=0.28u
X1 out2 in2.t8 VDD.t31 VDD.t30 pfet_03v3 ad=0.3341p pd=1.805u as=0.5654p ps=3.45u w=1.285u l=0.28u
X2 Q.t0 a_2849_203r# VSS.t6 VSS.t5 nfet_03v3 ad=0.3087p pd=2.01u as=2.81442p ps=15.045u w=1.02u l=0.28u
X3 VDD.t29 out2 a_2849_203r# VDD.t28 pfet_03v3 ad=0.3341p pd=1.805u as=0.3341p ps=1.805u w=1.285u l=0.28u
X4 CLKN CLK.t2 VDD.t1 VDD.t0 pfet_03v3 ad=0.3341p pd=1.805u as=6.973p ps=42.83u w=1.285u l=0.28u
X5 VDD.t14 CLKN CLKb.t1 VDD.t13 pfet_03v3 ad=0.5654p pd=3.45u as=0.3341p ps=1.805u w=1.285u l=0.28u
X6 VDD.t5 D.t2 a_828_987.t0 VDD.t4 pfet_03v3 ad=0.3341p pd=1.805u as=0.5654p ps=3.45u w=1.285u l=0.28u
X7 VDD.t25 out2 a_2044_987.t2 VDD.t24 pfet_03v3 ad=0.3341p pd=1.805u as=0.5654p ps=3.45u w=1.285u l=0.28u
X8 a_2044_987.t0 CLKb.t4 in2.t5 VDD.t8 pfet_03v3 ad=0.5654p pd=3.45u as=0.3341p ps=1.805u w=1.285u l=0.28u
X9 a_2849_203r# out2 VDD.t23 VDD.t22 pfet_03v3 ad=0.3341p pd=1.805u as=0.5654p ps=3.45u w=1.285u l=0.28u
X10 a_913_203r# D.t0 VSS.t3 VSS.t2 nfet_03v3 ad=0.3087p pd=2.01u as=2.81442p ps=15.045u w=1.02u l=0.28u
X11 a_2044_987.t3 out2 VDD.t27 VDD.t26 pfet_03v3 ad=0.3341p pd=1.805u as=0.3341p ps=1.805u w=1.285u l=0.28u
X12 a_828_987.t1 D.t1 VDD.t7 VDD.t6 pfet_03v3 ad=0.3341p pd=1.805u as=0.3341p ps=1.805u w=1.285u l=0.28u
X13 CLKN CLK.t0 VSS.t1 VSS.t0 nfet_03v3 ad=0.3087p pd=2.01u as=2.81442p ps=15.045u w=1.02u l=0.28u
X14 VDD.t20 in2.t7 out2 VDD.t19 pfet_03v3 ad=0.5654p pd=3.45u as=0.3341p ps=1.805u w=1.285u l=0.28u
X15 Q.t2 a_2849_203r# VDD.t10 VDD.t9 pfet_03v3 ad=0.3341p pd=1.805u as=0.3341p ps=1.805u w=1.285u l=0.28u
X16 in2.t0 CLKN a_2091_203r# VSS.t9 nfet_03v3 ad=0.3087p pd=2.01u as=0.53235p ps=3.25u w=1.02u l=0.28u
X17 VDD.t3 CLK.t1 CLKN VDD.t2 pfet_03v3 ad=0.3341p pd=1.805u as=0.3341p ps=1.805u w=1.285u l=0.28u
X18 in2.t3 CLKb.t3 a_913_203r# VSS.t4 nfet_03v3 ad=0.3087p pd=2.01u as=0.52065p ps=3.23u w=1.02u l=0.28u
X19 VDD.t12 a_2849_203r# Q.t1 VDD.t11 pfet_03v3 ad=6.973p pd=42.83u as=0.3341p ps=1.805u w=1.285u l=0.28u
X20 a_2091_203r# out2 VSS.t15 VSS.t14 nfet_03v3 ad=0.3087p pd=2.01u as=2.41237p ps=12.895u w=1.02u l=0.28u
X21 a_2849_203r# out2 VSS.t13 VSS.t12 nfet_03v3 ad=0.3087p pd=2.01u as=2.41237p ps=12.895u w=1.02u l=0.28u
X22 CLKb.t0 CLKN VDD.t16 VDD.t15 pfet_03v3 ad=0.3341p pd=1.805u as=0.3341p ps=1.805u w=1.285u l=0.28u
X23 CLKb.t2 CLKN VSS.t8 VSS.t7 nfet_03v3 ad=0.3087p pd=2.01u as=2.81442p ps=15.045u w=1.02u l=0.28u
X24 in2.t4 CLKb.t5 a_2044_987.t1 VDD.t21 pfet_03v3 ad=0.3341p pd=1.805u as=0.3341p ps=1.805u w=1.285u l=0.28u
X25 out2 in2.t6 VSS.t11 VSS.t10 nfet_03v3 ad=0.3087p pd=2.015u as=2.81442p ps=15.045u w=1.02u l=0.28u
X26 in2.t1 CLKN a_828_987.t3 VDD.t17 pfet_03v3 ad=0.3341p pd=1.805u as=0.3341p ps=1.805u w=1.285u l=0.28u
R0 Q.n7 Q.t0 120.001
R1 Q.n1 Q.n6 115.718
R2 Q.n9 Q.n8 67.4693
R3 Q.n8 Q.n7 34.8011
R4 Q.n7 Q.n6 20.0898
R5 Q Q.n0 15.3213
R6 Q.n0 Q.n1 5.1751
R7 Q.n4 Q.n1 2.89242
R8 Q Q.n5 7.88348
R9 Q.n4 Q.n3 1.97827
R10 Q.n8 Q.n2 7.5005
R11 Q.n9 Q.n6 4.52242
R12 Q.n3 Q.t0 1.09191
R13 Q.n3 Q.n2 1.96464
R14 Q.n5 Q.t2 3.03552
R15 Q.n5 Q.t1 3.03552
R16 Q.n0 Q.t0 14.0052
R17 Q.n0 Q.n2 4.18614
R18 Q.n4 Q.n9 1.72383
R19 D.n0 D.t1 64.435
R20 D.n0 D.t2 48.185
R21 D D.n0 38.5481
R22 D D.t0 13.3928
R23 CLK.n0 CLK.t1 82.5005
R24 CLK.n0 CLK.t2 39.6434
R25 CLK CLK.n0 30.5343
R26 CLK CLK.t0 13.4212
R27 VDD.n93 VDD.n92 1208.52
R28 VDD.n94 VDD.n25 164.505
R29 VDD.t2 VDD.n54 164.505
R30 VDD.n57 VDD.t2 164.505
R31 VDD.n61 VDD.n51 164.505
R32 VDD.n62 VDD.n61 164.505
R33 VDD.n66 VDD.n47 164.505
R34 VDD.n68 VDD.n44 164.505
R35 VDD.n71 VDD.n44 164.505
R36 VDD.n73 VDD.n41 164.505
R37 VDD.n76 VDD.n41 164.505
R38 VDD.n78 VDD.n40 164.505
R39 VDD.n83 VDD.n82 164.505
R40 VDD.n83 VDD.n36 164.505
R41 VDD.t9 VDD.n87 164.505
R42 VDD.t9 VDD.n33 164.505
R43 VDD.n91 VDD.n29 164.505
R44 VDD.n58 VDD.t13 141.005
R45 VDD.n63 VDD.t6 141.005
R46 VDD.n81 VDD.t21 141.005
R47 VDD.n86 VDD.t22 141.005
R48 VDD.n67 VDD.t17 117.504
R49 VDD.t18 VDD.n67 117.504
R50 VDD.n72 VDD.t30 117.504
R51 VDD.t19 VDD.n72 117.504
R52 VDD.n77 VDD.t24 117.504
R53 VDD.t26 VDD.n77 117.504
R54 VDD.t0 VDD.n25 94.0029
R55 VDD.n58 VDD.t15 94.0029
R56 VDD.n63 VDD.t4 94.0029
R57 VDD.t8 VDD.n81 94.0029
R58 VDD.t28 VDD.n86 94.0029
R59 VDD.t11 VDD.n29 94.0029
R60 VDD.n54 VDD.t0 70.5023
R61 VDD.t15 VDD.n57 70.5023
R62 VDD.t4 VDD.n62 70.5023
R63 VDD.n82 VDD.t8 70.5023
R64 VDD.n87 VDD.t28 70.5023
R65 VDD.n33 VDD.t11 70.5023
R66 VDD.t17 VDD.n66 47.0017
R67 VDD.n68 VDD.t18 47.0017
R68 VDD.t30 VDD.n71 47.0017
R69 VDD.n73 VDD.t19 47.0017
R70 VDD.t24 VDD.n76 47.0017
R71 VDD.n78 VDD.t26 47.0017
R72 VDD.t13 VDD.n51 23.5011
R73 VDD.t6 VDD.n47 23.5011
R74 VDD.n40 VDD.t21 23.5011
R75 VDD.n36 VDD.t22 23.5011
R76 VDD.n96 VDD.n24 23.3338
R77 VDD.n7 VDD.n24 23.3338
R78 VDD.n56 VDD.n7 23.3338
R79 VDD.n18 VDD.n53 6.5635
R80 VDD.n59 VDD.n53 23.3338
R81 VDD.n59 VDD.n52 23.3338
R82 VDD.n22 VDD.n52 6.5635
R83 VDD.n60 VDD.n50 23.3338
R84 VDD.n64 VDD.n50 23.3338
R85 VDD.n64 VDD.n16 6.5635
R86 VDD.n65 VDD.n48 23.3338
R87 VDD.n12 VDD.n46 6.5635
R88 VDD.n69 VDD.n46 23.3338
R89 VDD.n69 VDD.n45 23.3338
R90 VDD.n21 VDD.n45 6.5635
R91 VDD.n70 VDD.n43 23.3338
R92 VDD.n74 VDD.n43 23.3338
R93 VDD.n74 VDD.n20 6.5635
R94 VDD.n75 VDD.n42 23.3338
R95 VDD.n75 VDD.n39 23.3338
R96 VDD.n79 VDD.n13 6.5635
R97 VDD.n79 VDD.n37 23.3338
R98 VDD.n80 VDD.n14 6.5635
R99 VDD.n80 VDD.n35 23.3338
R100 VDD.n84 VDD.n35 23.3338
R101 VDD.n84 VDD.n19 6.5635
R102 VDD.n85 VDD.n34 23.3338
R103 VDD.n85 VDD.n23 23.3338
R104 VDD.n17 VDD.n23 6.5635
R105 VDD.n88 VDD.n11 23.3338
R106 VDD.n89 VDD.n11 23.3338
R107 VDD.n28 VDD.n15 11.6101
R108 VDD.n8 VDD.n26 12.9498
R109 VDD.n2 VDD.n95 10.5739
R110 VDD.n90 VDD.n0 16.7193
R111 VDD.n8 VDD.n3 11.7552
R112 VDD VDD.n49 15.2628
R113 VDD.n4 VDD.n38 15.2628
R114 VDD.n9 VDD.n93 15.2537
R115 VDD VDD.n96 15.0005
R116 VDD.n25 VDD.n24 15.0005
R117 VDD VDD.n24 15.0005
R118 VDD.n7 VDD.n54 15.0005
R119 VDD VDD.n7 15.0005
R120 VDD.t2 VDD.n56 15.0005
R121 VDD.n56 VDD.n18 6.5635
R122 VDD.n57 VDD.n53 15.0005
R123 VDD.n18 VDD 4.21975
R124 VDD.n59 VDD.n58 15.0005
R125 VDD VDD.n59 15.0005
R126 VDD.n52 VDD.n51 15.0005
R127 VDD VDD.n22 4.21975
R128 VDD.n61 VDD.n60 15.0005
R129 VDD.n60 VDD.n22 6.5635
R130 VDD.n62 VDD.n50 15.0005
R131 VDD.n50 VDD 15.0005
R132 VDD.n64 VDD.n63 15.0005
R133 VDD VDD.n16 4.21975
R134 VDD.n48 VDD.n47 15.0005
R135 VDD.n16 VDD.n48 6.5635
R136 VDD.n66 VDD.n65 15.0005
R137 VDD.n65 VDD.n12 6.5635
R138 VDD.n67 VDD.n46 15.0005
R139 VDD.n12 VDD.n4 4.21975
R140 VDD.n69 VDD.n68 15.0005
R141 VDD.n4 VDD.n69 15.0005
R142 VDD.n45 VDD.n44 15.0005
R143 VDD.n4 VDD.n21 4.21975
R144 VDD.n71 VDD.n70 15.0005
R145 VDD.n70 VDD.n21 6.5635
R146 VDD.n72 VDD.n43 15.0005
R147 VDD.n43 VDD.n4 15.0005
R148 VDD.n74 VDD.n73 15.0005
R149 VDD.n4 VDD.n20 4.21975
R150 VDD.n42 VDD.n41 15.0005
R151 VDD.n20 VDD.n42 6.5635
R152 VDD.n76 VDD.n75 15.0005
R153 VDD.n75 VDD.n4 15.0005
R154 VDD.n77 VDD.n39 15.0005
R155 VDD.n39 VDD.n13 6.5635
R156 VDD.n79 VDD.n78 15.0005
R157 VDD.n4 VDD.n13 4.21975
R158 VDD.n40 VDD.n37 15.0005
R159 VDD.n14 VDD.n37 6.5635
R160 VDD.n81 VDD.n80 15.0005
R161 VDD.n14 VDD.n4 4.21975
R162 VDD.n82 VDD.n35 15.0005
R163 VDD.n35 VDD.n4 15.0005
R164 VDD.n84 VDD.n83 15.0005
R165 VDD.n4 VDD.n19 4.21975
R166 VDD.n36 VDD.n34 15.0005
R167 VDD.n19 VDD.n34 6.5635
R168 VDD.n86 VDD.n85 15.0005
R169 VDD.n85 VDD.n4 15.0005
R170 VDD.n87 VDD.n23 15.0005
R171 VDD.n4 VDD.n17 4.21975
R172 VDD.n88 VDD.t9 15.0005
R173 VDD.n17 VDD.n88 6.5635
R174 VDD.n33 VDD.n11 15.0005
R175 VDD.n4 VDD.n11 15.0005
R176 VDD.n89 VDD.n29 15.0005
R177 VDD.n89 VDD.n15 6.5635
R178 VDD.n6 VDD.n15 4.21975
R179 VDD.n6 VDD.n90 15.0005
R180 VDD.n91 VDD.n0 15.0005
R181 VDD.n0 VDD.n10 5.52732
R182 VDD.n6 VDD.n10 4.73784
R183 VDD.n92 VDD.n91 15.0005
R184 VDD.n9 VDD.n8 4.30808
R185 VDD.n2 VDD 4.73784
R186 VDD.n3 VDD.n1 5.36889
R187 VDD.n2 VDD.n1 5.52732
R188 VDD.n94 VDD.n3 4.81705
R189 VDD.n30 VDD.n5 12.9188
R190 VDD.n4 VDD.t20 10.8973
R191 VDD.n4 VDD.t31 10.8973
R192 VDD.n4 VDD.t23 10.895
R193 VDD VDD.t14 10.8927
R194 VDD.n27 VDD 7.85998
R195 VDD.n4 VDD.n32 7.85998
R196 VDD VDD.n55 7.85998
R197 VDD.n6 VDD.n31 7.85772
R198 VDD.n92 VDD.n5 6.64275
R199 VDD.n93 VDD.n26 6.5635
R200 VDD.n90 VDD.n30 6.38684
R201 VDD.n96 VDD.n95 5.04708
R202 VDD.n10 VDD.n28 10.5739
R203 VDD.n95 VDD.n94 4.97796
R204 VDD.n91 VDD.n28 4.97796
R205 VDD.n6 VDD.n5 4.52391
R206 VDD.n91 VDD.n30 4.30808
R207 VDD.n94 VDD.n26 4.21975
R208 VDD.n31 VDD.t12 3.03552
R209 VDD.n27 VDD.t1 3.03552
R210 VDD.n32 VDD.t29 3.03552
R211 VDD.n32 VDD.t10 3.03552
R212 VDD.n49 VDD.t5 3.03552
R213 VDD.n49 VDD.t7 3.03552
R214 VDD.n55 VDD.t3 3.03552
R215 VDD.n55 VDD.t16 3.03552
R216 VDD.n38 VDD.t25 3.03552
R217 VDD.n38 VDD.t27 3.03552
R218 VDD.n1 VDD.n27 2.88292
R219 VDD.n31 VDD.n0 2.88292
R220 VDD.n4 VDD 1.65063
R221 VDD.n6 VDD.n4 1.4981
R222 VDD.n9 VDD 1.46012
R223 VSS.n103 VSS.n102 1236.02
R224 VSS.n106 VSS.n105 513.399
R225 VSS.n60 VSS.n59 513.399
R226 VSS.n61 VSS.n60 513.399
R227 VSS.n65 VSS.n56 513.399
R228 VSS.n66 VSS.n65 513.399
R229 VSS.n67 VSS.n66 513.399
R230 VSS.n71 VSS.n70 513.399
R231 VSS.n72 VSS.n71 513.399
R232 VSS.n75 VSS.n53 513.399
R233 VSS.n76 VSS.n75 513.399
R234 VSS.n77 VSS.n51 513.399
R235 VSS.n80 VSS.n51 513.399
R236 VSS.n81 VSS.n80 513.399
R237 VSS.n82 VSS.n49 513.399
R238 VSS.n85 VSS.n49 513.399
R239 VSS.n86 VSS.n85 513.399
R240 VSS.n87 VSS.n45 513.399
R241 VSS.n90 VSS.n45 513.399
R242 VSS.n92 VSS.n91 513.399
R243 VSS.n92 VSS.n44 513.399
R244 VSS.n96 VSS.n95 513.399
R245 VSS.n97 VSS.n96 513.399
R246 VSS.n97 VSS.n41 513.399
R247 VSS.n87 VSS.t9 495.063
R248 VSS.n70 VSS.t2 490.481
R249 VSS.t10 VSS.n76 421.721
R250 VSS.n61 VSS.t7 380.466
R251 VSS.n91 VSS.t12 343.795
R252 VSS.n44 VSS.t5 325.459
R253 VSS.n59 VSS.t0 288.788
R254 VSS.t14 VSS.n81 288.788
R255 VSS.n72 VSS.t4 265.868
R256 VSS.t4 VSS.n53 247.532
R257 VSS.n106 VSS.t0 224.613
R258 VSS.n82 VSS.t14 224.613
R259 VSS.n95 VSS.t5 187.941
R260 VSS.t12 VSS.n90 169.606
R261 VSS.t7 VSS.n56 132.935
R262 VSS.n77 VSS.t10 91.6789
R263 VSS.n98 VSS.n27 6.5635
R264 VSS.n84 VSS.n48 23.3338
R265 VSS.n88 VSS.n26 6.5635
R266 VSS.n88 VSS.n47 23.3338
R267 VSS.n79 VSS.n37 23.3338
R268 VSS.n73 VSS.n54 23.3338
R269 VSS.n24 VSS.n23 6.5635
R270 VSS.n74 VSS.n23 23.3338
R271 VSS.n25 VSS.n35 6.5635
R272 VSS.n107 VSS.n40 23.3338
R273 VSS.n93 VSS.n36 23.251
R274 VSS.n89 VSS.n28 6.53281
R275 VSS.n67 VSS.t2 22.9201
R276 VSS.n29 VSS.n14 6.49747
R277 VSS.n84 VSS.n21 6.43489
R278 VSS.n98 VSS.n38 22.3122
R279 VSS.n68 VSS.n32 22.257
R280 VSS.n33 VSS.n32 6.34389
R281 VSS.n79 VSS.n34 6.30231
R282 VSS.n78 VSS.n35 21.5668
R283 VSS.n63 VSS.n62 21.3183
R284 VSS.n22 VSS.n54 6.18467
R285 VSS.n94 VSS.n30 6.17512
R286 VSS.n83 VSS.n31 6.13672
R287 VSS.n107 VSS.n39 20.3795
R288 VSS.n89 VSS.n0 19.88
R289 VSS.n15 VSS.n14 18.4342
R290 VSS.t9 VSS.n86 18.3362
R291 VSS.n6 VSS.n5 15.9041
R292 VSS.n17 VSS.n40 15.8338
R293 VSS.n99 VSS.n42 15.8338
R294 VSS VSS.n103 15.2537
R295 VSS.n102 VSS.n2 15.2537
R296 VSS.n107 VSS.n106 15.0005
R297 VSS VSS.n107 15.0005
R298 VSS.n105 VSS.n40 15.0005
R299 VSS.n40 VSS 15.0005
R300 VSS.n60 VSS.n14 15.0005
R301 VSS VSS.n29 4.25277
R302 VSS.n59 VSS.n39 15.0005
R303 VSS.n16 VSS 4.54513
R304 VSS.n62 VSS.n61 15.0005
R305 VSS.n62 VSS.n29 6.49747
R306 VSS.n65 VSS.n64 15.0005
R307 VSS.n64 VSS.n33 6.34389
R308 VSS.n63 VSS.n56 15.0005
R309 VSS VSS.n13 3.69536
R310 VSS.n66 VSS.n32 15.0005
R311 VSS VSS.n33 4.32955
R312 VSS.n70 VSS.n69 15.0005
R313 VSS.n69 VSS.n22 6.18467
R314 VSS.n68 VSS.n67 15.0005
R315 VSS VSS.n11 3.07507
R316 VSS.n76 VSS.n35 15.0005
R317 VSS VSS.n25 4.21975
R318 VSS.n75 VSS.n74 15.0005
R319 VSS.n74 VSS.n25 6.5635
R320 VSS.n23 VSS.n53 15.0005
R321 VSS VSS.n24 4.21975
R322 VSS.n73 VSS.n72 15.0005
R323 VSS.n24 VSS.n73 6.5635
R324 VSS.n71 VSS.n54 15.0005
R325 VSS.n22 VSS 4.40916
R326 VSS.n7 VSS.n51 15.0005
R327 VSS.n34 VSS.n7 6.30231
R328 VSS.n78 VSS.n77 15.0005
R329 VSS.n9 VSS 3.50804
R330 VSS.n81 VSS.n37 15.0005
R331 VSS.n31 VSS.n37 6.13672
R332 VSS.n80 VSS.n79 15.0005
R333 VSS.n34 VSS 4.35035
R334 VSS.n5 VSS.n49 15.0005
R335 VSS.n21 VSS.n5 6.43489
R336 VSS.n83 VSS.n82 15.0005
R337 VSS.n31 VSS 4.43314
R338 VSS.n47 VSS.n45 15.0005
R339 VSS.n28 VSS.n47 6.53281
R340 VSS.n88 VSS.n87 15.0005
R341 VSS VSS.n26 4.21975
R342 VSS.n86 VSS.n48 15.0005
R343 VSS.n48 VSS.n26 6.5635
R344 VSS.n85 VSS.n84 15.0005
R345 VSS.n21 VSS 4.28405
R346 VSS.n91 VSS.n0 15.0005
R347 VSS VSS.n1 1.78457
R348 VSS.n90 VSS.n89 15.0005
R349 VSS.n28 VSS 4.23509
R350 VSS.n44 VSS.n36 15.0005
R351 VSS.n30 VSS.n36 6.17512
R352 VSS.n93 VSS.n92 15.0005
R353 VSS.n96 VSS.n38 15.0005
R354 VSS VSS.n4 3.04501
R355 VSS.n95 VSS.n94 15.0005
R356 VSS.n30 VSS 4.41394
R357 VSS.n42 VSS.n41 15.0005
R358 VSS.n27 VSS.n42 6.5635
R359 VSS.n98 VSS.n97 15.0005
R360 VSS VSS.n27 4.21975
R361 VSS.n20 VSS.n2 4.21975
R362 VSS.n100 VSS.n20 13.1265
R363 VSS.n99 VSS.n2 15.0005
R364 VSS VSS.n17 15.0005
R365 VSS VSS.n19 4.21975
R366 VSS.n4 VSS.n38 5.86897
R367 VSS.n68 VSS.n11 5.77878
R368 VSS.n64 VSS.n12 12.2897
R369 VSS.n8 VSS.n7 10.6632
R370 VSS.n3 VSS.t6 10.5005
R371 VSS.n0 VSS.t13 10.5005
R372 VSS.n6 VSS.t15 10.5005
R373 VSS.n8 VSS.t11 10.5005
R374 VSS.n10 VSS.t3 10.5005
R375 VSS.n12 VSS.t8 10.5005
R376 VSS.n15 VSS.t1 10.5005
R377 VSS.n9 VSS.n78 4.47987
R378 VSS.n63 VSS.n13 3.91791
R379 VSS.n16 VSS.n15 0.684809
R380 VSS.n13 VSS.n12 1.95946
R381 VSS.n11 VSS.n10 2.88989
R382 VSS.n9 VSS.n8 2.24044
R383 VSS VSS.n6 7.5005
R384 VSS.n1 VSS.n0 2.73081
R385 VSS.n4 VSS.n3 2.93499
R386 VSS.n3 VSS.n43 6.6005
R387 VSS.n0 VSS.n46 6.6005
R388 VSS.n6 VSS.n50 6.6005
R389 VSS.n10 VSS.n55 6.6005
R390 VSS.n15 VSS.n58 6.6005
R391 VSS.n103 VSS.n18 6.5635
R392 VSS.n102 VSS.n101 6.5635
R393 VSS.n104 VSS.n17 6.5635
R394 VSS.n104 VSS.n19 13.1265
R395 VSS.n19 VSS.n18 13.1265
R396 VSS.n100 VSS.n99 6.5635
R397 VSS.n101 VSS.n20 13.1265
R398 VSS.n12 VSS.n57 7.0505
R399 VSS.n8 VSS.n52 7.0505
R400 VSS.n93 VSS.n1 7.67488
R401 VSS.n69 VSS.n10 6.59508
R402 VSS.n94 VSS.n3 6.23363
R403 VSS.n6 VSS.n83 4.78785
R404 VSS.n101 VSS.n41 4.21975
R405 VSS.n100 VSS.n41 4.21975
R406 VSS.n105 VSS.n104 4.21975
R407 VSS.n105 VSS.n18 4.21975
R408 VSS.n16 VSS.n39 1.36862
R409 VSS.n2 VSS 1.18351
R410 a_2044_987.t2 a_2044_987.n1 11.571
R411 a_2044_987.n1 a_2044_987.t0 11.5552
R412 a_2044_987.n1 a_2044_987.n0 7.5005
R413 a_2044_987.n0 a_2044_987.t1 3.03552
R414 a_2044_987.n0 a_2044_987.t3 3.03552
R415 a_828_987.n0 a_828_987.t0 11.571
R416 a_828_987.n0 a_828_987.t2 11.5552
R417 a_828_987.n1 a_828_987.n0 7.5005
R418 a_828_987.n1 a_828_987.t3 3.03552
R419 a_828_987.t1 a_828_987.n1 3.03552
R420 CLKb.n9 CLKb.t2 120.001
R421 CLKb.n1 CLKb.n8 115.718
R422 CLKb.n6 CLKb.t4 105.596
R423 CLKb.n11 CLKb.n10 67.4693
R424 CLKb.n6 CLKb.t5 65.3576
R425 CLKb.n7 CLKb.n6 53.726
R426 CLKb.n10 CLKb.n9 34.8011
R427 CLKb CLKb.n0 30.5882
R428 CLKb.n7 CLKb.t3 24.2337
R429 CLKb CLKb.n5 23.7643
R430 CLKb.n9 CLKb.n8 20.0898
R431 CLKb CLKb.n7 16.7787
R432 CLKb.n0 CLKb.n1 5.1751
R433 CLKb.n4 CLKb.n1 2.89242
R434 CLKb.n4 CLKb.n3 1.97827
R435 CLKb.n10 CLKb.n2 7.5005
R436 CLKb.n11 CLKb.n8 4.52242
R437 CLKb.n3 CLKb.t2 1.09191
R438 CLKb.n3 CLKb.n2 1.96464
R439 CLKb.n5 CLKb.t0 3.03552
R440 CLKb.n5 CLKb.t1 3.03552
R441 CLKb.n0 CLKb.t2 14.0052
R442 CLKb.n0 CLKb.n2 4.18614
R443 CLKb.n4 CLKb.n11 1.72383
R444 in2.t3 in2.n27 229.018
R445 in2.n15 in2.n9 210
R446 in2.n29 in2.n28 210
R447 in2.n11 in2.n1 202.5
R448 in2.t3 in2.n6 4.02627
R449 in2.n18 in2.n1 113.05
R450 in2.n9 in2.n1 112.501
R451 in2.n12 in2.n11 112.501
R452 in2.n28 in2.n25 112.501
R453 in2.n22 in2.t7 82.5005
R454 in2.n24 in2.n22 55.6093
R455 in2.n22 in2.t8 39.6434
R456 in2.n5 in2.n31 10.8079
R457 in2.n17 in2.n4 34.259
R458 in2.n19 in2.t0 32.5005
R459 in2.n31 in2.n29 31.9491
R460 in2.n21 in2.n7 30.9904
R461 in2.n21 in2.n20 30.7165
R462 in2.n16 in2.n15 29.036
R463 in2.n0 in2.n24 24.0445
R464 in2.n15 in2.n14 22.7684
R465 in2.n29 in2.n27 22.7684
R466 in2.n13 in2.n12 22.5005
R467 in2.n19 in2.n18 19.0201
R468 in2.n13 in2.n4 17.1346
R469 in2 in2.n21 16.0939
R470 in2.n32 in2.t3 15.2591
R471 in2.n24 in2.n23 15.0005
R472 in2.n0 in2.n32 15.0005
R473 in2.n14 in2.n13 11.777
R474 in2.n3 in2.n17 7.5005
R475 in2.n14 in2.n10 7.5005
R476 in2.n11 in2.n10 7.5005
R477 in2.n12 in2.t0 7.5005
R478 in2.n27 in2.n26 7.5005
R479 in2.n25 in2.n6 209.323
R480 in2.n20 in2.n19 6.98326
R481 in2.n2 in2.n1 10.3951
R482 in2.t3 in2.n5 0.379787
R483 in2 in2.t6 13.6612
R484 in2.t0 in2.n4 4.82859
R485 in2.n6 in2.n26 0.252579
R486 in2.n17 in2.n16 4.23032
R487 in2.n10 in2.t0 4.16717
R488 in2.n10 in2.n9 4.16717
R489 in2.n28 in2.n26 4.16717
R490 in2.t0 in2.n2 0.176504
R491 in2.n20 in2.n1 3.87981
R492 in2.n32 in2.n25 3.87981
R493 in2.n5 in2.n25 9.36437
R494 in2.n18 in2.n3 4.17236
R495 in2.n3 in2.n2 3.52546
R496 in2.n23 in2.t1 3.03552
R497 in2.n23 in2.t2 3.03552
R498 in2.n7 in2.t4 3.03552
R499 in2.n7 in2.t5 3.03552
R500 in2.n31 in2.n30 2.72827
R501 in2 in2.n0 1.94364
R502 in2.n16 in2.n8 1.54101
C0 VDD out2 1.17152f
C1 CLKb D 0.31438f
C2 CLKb VDD 0.81905f
C3 D a_913_203r# 0.10732f
C4 CLKN D 0.25234f
C5 CLKN VDD 1.24018f
C6 in2 out2 0.8376f
C7 a_2849_203r# out2 0.34174f
C8 D VDD 0.37316f
C9 CLKb in2 0.54419f
C10 a_2091_203r# out2 0.2354f
C11 VDD Q 0.30419f
C12 CLK CLKN 0.29463f
C13 CLKb out2 0.5454f
C14 CLK VDD 0.52851f
C15 in2 CLKN 0.61843f
C16 in2 VDD 0.59396f
C17 CLKN out2 0.32612f
C18 a_2849_203r# VDD 0.71551f
C19 a_2849_203r# Q 0.29499f
C20 CLKb CLKN 0.93536f
C21 Q VSS 0.50534f
C22 D VSS 0.90528f
C23 CLK VSS 0.97706f
C24 VDD VSS 10.11403f
C25 a_2091_203r# VSS 0.14843f
C26 a_913_203r# VSS 0.46812f
C27 CLKb VSS 1.13544f
C28 out2 VSS 0.18101f
C29 in2 VSS 1.20725f
C30 in2.n0 VSS 0.34265f
C31 in2.t3 VSS 0.32087f
C32 in2.t5 VSS 0.11658f
C33 in2.n7 VSS 0.10586f
C34 in2.n21 VSS 0.36416f
C35 in2.n22 VSS 0.11202f
C36 in2.t2 VSS 0.58909f
C37 in2.n24 VSS 0.26102f
C38 CLKb.n5 VSS 0.20543f
C39 CLKb.n6 VSS 0.46075f
C40 CLKb.n7 VSS 0.98078f
C41 CLKb.n10 VSS 0.1243f
C42 a_828_987.t2 VSS 0.69467f
C43 a_828_987.t0 VSS 0.19019f
C44 a_828_987.n0 VSS 0.444f
C45 a_828_987.t1 VSS 0.10132f
C46 a_2044_987.t0 VSS 0.21659f
C47 a_2044_987.t1 VSS 0.10738f
C48 a_2044_987.n1 VSS 0.42668f
C49 a_2044_987.t2 VSS 0.13759f
C50 VSS.t6 VSS 0.2869f
C51 VSS.t1 VSS 0.13864f
C52 VSS.t3 VSS 0.18966f
C53 VSS.t11 VSS 0.18101f
C54 VDD.n4 VSS 0.51924f
C55 VDD.n25 VSS 0.11006f
C56 VDD.n29 VSS 0.11006f
C57 VDD.t10 VSS 0.27834f
C58 VDD.t29 VSS 0.54644f
C59 VDD.n33 VSS 0.10005f
C60 VDD.n41 VSS 0.14007f
C61 VDD.n44 VSS 0.14007f
C62 VDD.n54 VSS 0.10005f
C63 VDD.t2 VSS 0.14007f
C64 VDD.n57 VSS 0.10005f
C65 VDD.n58 VSS 0.10005f
C66 VDD.n61 VSS 0.14007f
C67 VDD.n62 VSS 0.10005f
C68 VDD.n63 VSS 0.10005f
C69 VDD.n67 VSS 0.10005f
C70 VDD.n72 VSS 0.10005f
C71 VDD.n77 VSS 0.10005f
C72 VDD.n81 VSS 0.10005f
C73 VDD.n82 VSS 0.10005f
C74 VDD.n83 VSS 0.14007f
C75 VDD.n86 VSS 0.10005f
C76 VDD.n87 VSS 0.10005f
C77 VDD.t9 VSS 0.14007f
C78 VDD.n91 VSS 0.22262f
C79 VDD.n92 VSS 0.12995f
C80 VDD.n93 VSS 0.12995f
C81 VDD.n94 VSS 0.1826f
C82 D.n0 VSS 0.25429f
C83 Q.t0 VSS 0.29717f
C84 Q.t2 VSS 0.29507f
.ends
