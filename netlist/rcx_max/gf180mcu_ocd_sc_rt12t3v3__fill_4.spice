* NGSPICE file created from gf180mcu_ocd_sc_rt12t3v3__fill_4.ext - technology: gf180mcuD

.subckt gf180mcu_ocd_sc_rt12t3v3__fill_4 VDD VSS
R0 VDD.n16 VDD.n13 195.548
R1 VDD.n17 VDD.n16 194.22
R2 VDD.n18 VDD.n17 194.22
R3 VDD.n18 VDD.n9 194.22
R4 VDD.n22 VDD.n9 194.22
R5 VDD.n15 VDD.n10 23.3338
R6 VDD.n2 VDD.n10 6.5635
R7 VDD.n20 VDD.n19 23.3338
R8 VDD.n23 VDD.n7 23.3338
R9 VDD.n11 VDD.n0 23.3338
R10 VDD.n0 VDD.n4 23.3338
R11 VDD.n4 VDD.n6 23.3338
R12 VDD.n14 VDD.n13 18.9873
R13 VDD.n13 VDD.n12 18.9873
R14 VDD.n5 VDD.n20 5.18282
R15 VDD.n23 VDD.n6 15.8338
R16 VDD.n23 VDD.n22 15.0005
R17 VDD VDD.n23 15.0005
R18 VDD.n7 VDD.n1 15.0005
R19 VDD.n1 VDD.n3 4.21975
R20 VDD.n16 VDD.n15 15.0005
R21 VDD.n17 VDD.n10 15.0005
R22 VDD.n1 VDD.n2 4.21975
R23 VDD.n19 VDD.n18 15.0005
R24 VDD.n19 VDD.n2 6.5635
R25 VDD.n20 VDD.n9 15.0005
R26 VDD.n5 VDD.n1 4.91009
R27 VDD.n9 VDD.n6 15.0005
R28 VDD.n6 VDD 15.0005
R29 VDD.n18 VDD.n4 15.0005
R30 VDD VDD.n4 15.0005
R31 VDD.n17 VDD.n0 15.0005
R32 VDD VDD.n0 15.0005
R33 VDD.n16 VDD.n11 15.0005
R34 VDD.n21 VDD.n7 6.5635
R35 VDD.n5 VDD.n8 11.7458
R36 VDD.n21 VDD.n3 13.1265
R37 VDD.n3 VDD.n8 13.1265
R38 VDD.n12 VDD.n11 6.53249
R39 VDD.n15 VDD.n14 6.53249
R40 VDD.n14 VDD.n1 4.52391
R41 VDD.n12 VDD 4.52391
R42 VDD.n22 VDD.n21 4.21975
R43 VDD.n22 VDD.n8 4.21975
R44 VDD VDD.n1 1.63677
R45 VSS.n21 VSS.n10 513.399
R46 VSS.n13 VSS.n10 513.399
R47 VSS.n16 VSS.n13 513.399
R48 VSS.n17 VSS.n16 513.399
R49 VSS.n2 VSS.n19 166.933
R50 VSS.n22 VSS.n9 23.3338
R51 VSS.n14 VSS.n5 6.5635
R52 VSS.n15 VSS.n14 23.3338
R53 VSS.n18 VSS.n4 23.3338
R54 VSS.n12 VSS.n1 13.1265
R55 VSS.n22 VSS.n8 15.8338
R56 VSS.n19 VSS.n0 15.2537
R57 VSS VSS.n2 15.2537
R58 VSS.n0 VSS.n7 4.21975
R59 VSS.n16 VSS.n15 15.0005
R60 VSS.n15 VSS.n7 6.5635
R61 VSS.n14 VSS.n13 15.0005
R62 VSS.n0 VSS.n5 4.21975
R63 VSS.n10 VSS.n9 15.0005
R64 VSS.n9 VSS.n5 6.5635
R65 VSS.n22 VSS.n21 15.0005
R66 VSS VSS.n22 15.0005
R67 VSS.n8 VSS 15.0005
R68 VSS.n3 VSS 4.21975
R69 VSS.n0 VSS.n1 4.21975
R70 VSS.n18 VSS.n17 15.0005
R71 VSS.n18 VSS.n1 6.5635
R72 VSS.n0 VSS.n4 15.0005
R73 VSS.n20 VSS.n2 6.5635
R74 VSS.n11 VSS.n8 6.5635
R75 VSS.n3 VSS.n11 13.1265
R76 VSS.n20 VSS.n3 13.1265
R77 VSS.n19 VSS.n12 6.5635
R78 VSS.n6 VSS.n4 5.18282
R79 VSS.n7 VSS.n6 11.7458
R80 VSS.n17 VSS.n6 4.91009
R81 VSS.n21 VSS.n11 4.21975
R82 VSS.n21 VSS.n20 4.21975
R83 VSS.n17 VSS.n12 4.21975
R84 VSS VSS.n0 1.63677
C0 VDD VSS 2.01404f
.ends
