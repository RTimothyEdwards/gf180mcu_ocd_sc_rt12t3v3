* NGSPICE file created from gf180mcu_ocd_sc_rt12t3v3__inv_1.ext - technology: gf180mcuD

.subckt gf180mcu_ocd_sc_rt12t3v3__inv_1 A Y VDD VSS
X0 VDD.t3 A.t1 Y.t0 VDD.t2 pfet_03v3 ad=2.7424p pd=12.83u as=0.3341p ps=1.805u w=1.285u l=0.28u
X1 Y.t2 A.t2 VDD.t1 VDD.t0 pfet_03v3 ad=0.3341p pd=1.805u as=2.7424p ps=12.83u w=1.285u l=0.28u
X2 Y.t1 A.t0 VSS.t1 VSS.t0 nfet_03v3 ad=0.3087p pd=2.01u as=4.22095p ps=23.13u w=1.02u l=0.28u
R0 Y.n7 Y.t1 120.001
R1 Y.n1 Y.n6 115.718
R2 Y.n9 Y.n8 67.4693
R3 Y.n8 Y.n7 34.8011
R4 Y.n7 Y.n6 20.0898
R5 Y Y.n0 15.3125
R6 Y.n0 Y.n1 5.1751
R7 Y.n4 Y.n1 2.89242
R8 Y Y.n5 7.94916
R9 Y.n4 Y.n3 1.97827
R10 Y.n8 Y.n2 7.5005
R11 Y.n9 Y.n6 4.52242
R12 Y.n3 Y.t1 1.09191
R13 Y.n3 Y.n2 1.96464
R14 Y.n5 Y.t2 3.03552
R15 Y.n5 Y.t0 3.03552
R16 Y.n0 Y.t1 14.0052
R17 Y.n0 Y.n2 4.18614
R18 Y.n4 Y.n9 1.72383
R19 A.n0 A.t1 82.5005
R20 A.n0 A.t2 39.6434
R21 A A.n0 18.7416
R22 A A.t0 13.5085
R23 VDD.n18 VDD.n14 177.614
R24 VDD.n28 VDD.n13 164.505
R25 VDD.n23 VDD.n22 164.505
R26 VDD.n21 VDD.n0 164.505
R27 VDD.t0 VDD.n13 141.005
R28 VDD.t2 VDD.n21 117.504
R29 VDD.n22 VDD.t2 47.0017
R30 VDD.n23 VDD.t0 23.5011
R31 VDD.n29 VDD.n12 23.3338
R32 VDD.n24 VDD.n10 6.5635
R33 VDD.n24 VDD.n16 23.3338
R34 VDD.n20 VDD.n16 23.3338
R35 VDD.n9 VDD.n19 11.5508
R36 VDD.n7 VDD.n17 12.8718
R37 VDD VDD.n18 15.2537
R38 VDD.n29 VDD.n28 15.0005
R39 VDD VDD.n29 15.0005
R40 VDD.n13 VDD.n12 15.0005
R41 VDD.n12 VDD.n10 6.5635
R42 VDD.n24 VDD.n23 15.0005
R43 VDD VDD.n10 4.21975
R44 VDD.n22 VDD.n16 15.0005
R45 VDD.n16 VDD 15.0005
R46 VDD.n21 VDD.n20 15.0005
R47 VDD.n20 VDD.n9 6.5635
R48 VDD VDD.n9 4.21975
R49 VDD.n11 VDD 15.0005
R50 VDD.n5 VDD.n6 4.42249
R51 VDD.n8 VDD.n6 5.29026
R52 VDD.n28 VDD.n14 15.0005
R53 VDD VDD.n7 4.34708
R54 VDD.n1 VDD.n0 5.07653
R55 VDD.n4 VDD.n1 4.84994
R56 VDD.n4 VDD.n2 5.001
R57 VDD VDD.n2 5.001
R58 VDD.n19 VDD.n2 9.98825
R59 VDD.n29 VDD.n11 14.7401
R60 VDD.n1 VDD.n7 11.1583
R61 VDD.n26 VDD.n15 12.7814
R62 VDD.n15 VDD.n6 10.6714
R63 VDD.n25 VDD 7.85998
R64 VDD VDD.n3 7.85772
R65 VDD.n26 VDD.n14 6.64275
R66 VDD.n18 VDD.n17 6.5635
R67 VDD.n28 VDD.n27 5.21839
R68 VDD.n19 VDD.n0 5.00762
R69 VDD.n27 VDD.n11 4.56622
R70 VDD.n27 VDD.n5 4.56622
R71 VDD.n8 VDD.n26 4.52391
R72 VDD.n28 VDD.n15 4.37679
R73 VDD.n17 VDD.n0 4.21975
R74 VDD.n25 VDD.t1 3.03552
R75 VDD.n3 VDD.t3 3.03552
R76 VDD.n4 VDD.n3 2.77131
R77 VDD.n5 VDD.n25 2.6876
R78 VDD.n8 VDD 1.98705
R79 VSS.n15 VSS.n12 453.695
R80 VSS.n23 VSS.n8 452.736
R81 VSS.n18 VSS.n12 452.736
R82 VSS.t0 VSS.n8 254.665
R83 VSS.n18 VSS.t0 198.072
R84 VSS.n17 VSS.n5 23.3338
R85 VSS.n17 VSS.n13 23.3338
R86 VSS.n4 VSS.n19 6.5635
R87 VSS.n19 VSS.n11 23.3338
R88 VSS.n22 VSS.n6 22.3675
R89 VSS.n25 VSS.n1 20.9317
R90 VSS.n16 VSS.n15 19.7293
R91 VSS.n15 VSS.n14 19.7293
R92 VSS.n5 VSS.n7 15.8338
R93 VSS.n21 VSS.n20 15.8338
R94 VSS VSS.n25 15.0005
R95 VSS.n7 VSS 15.0005
R96 VSS.n23 VSS.n22 15.0005
R97 VSS.n3 VSS 3.01553
R98 VSS.n23 VSS.n1 15.0005
R99 VSS.n1 VSS 15.0005
R100 VSS VSS.n21 15.0005
R101 VSS VSS.n6 15.0005
R102 VSS.n12 VSS.n11 15.0005
R103 VSS.n19 VSS.n18 15.0005
R104 VSS.n4 VSS.n0 4.21975
R105 VSS.n20 VSS.n8 15.0005
R106 VSS.n20 VSS.n4 6.5635
R107 VSS.n5 VSS.n8 15.0005
R108 VSS VSS.n5 15.0005
R109 VSS.n18 VSS.n17 15.0005
R110 VSS.n17 VSS 15.0005
R111 VSS.n13 VSS.n12 15.0005
R112 VSS.n22 VSS.n3 5.95742
R113 VSS.n2 VSS.t1 10.5005
R114 VSS.n3 VSS.n2 2.97921
R115 VSS.n2 VSS.n10 6.6005
R116 VSS.n24 VSS.n7 6.5635
R117 VSS.n6 VSS.n9 6.5635
R118 VSS.n21 VSS.n9 6.5635
R119 VSS.n25 VSS.n24 6.5635
R120 VSS.n14 VSS.n11 6.53249
R121 VSS.n16 VSS.n13 6.53249
R122 VSS.n2 VSS.n1 5.87219
R123 VSS VSS.n16 4.52391
R124 VSS.n14 VSS.n0 4.52391
R125 VSS.n24 VSS.n23 4.21975
R126 VSS.n23 VSS.n9 4.21975
R127 VSS VSS.n0 1.16544
C0 A VDD 0.45125f
C1 Y VDD 0.29942f
C2 A Y 0.30612f
C3 Y VSS 0.52095f
C4 A VSS 0.97362f
C5 VDD VSS 2.29461f
C6 VSS.t1 VSS 0.1242f
C7 VDD.n0 VSS 0.1067f
C8 VDD.n28 VSS 0.1067f
C9 Y.t1 VSS 0.13434f
.ends
