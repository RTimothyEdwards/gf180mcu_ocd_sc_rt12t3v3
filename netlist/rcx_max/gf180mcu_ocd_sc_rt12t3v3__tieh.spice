* NGSPICE file created from gf180mcu_ocd_sc_rt12t3v3__tieh.ext - technology: gf180mcuD

.subckt gf180mcu_ocd_sc_rt12t3v3__tieh Y VDD VSS
X0 VDD.t3 a_93_147# Y.t1 VDD.t2 pfet_03v3 ad=2.7424p pd=12.83u as=0.3341p ps=1.805u w=1.285u l=0.28u
X1 Y.t0 a_93_147# VDD.t1 VDD.t0 pfet_03v3 ad=0.3341p pd=1.805u as=2.7424p ps=12.83u w=1.285u l=0.28u
X2 a_93_147# a_93_147# VSS.t1 VSS.t0 nfet_03v3 ad=0.3087p pd=2.01u as=4.22095p ps=23.13u w=1.02u l=0.28u
R0 Y Y.n0 7.94916
R1 Y.n0 Y.t1 3.03552
R2 Y.n0 Y.t0 3.03552
R3 VDD.n18 VDD.n14 177.614
R4 VDD.n28 VDD.n13 164.505
R5 VDD.n23 VDD.n22 164.505
R6 VDD.n21 VDD.n0 164.505
R7 VDD.t0 VDD.n13 141.005
R8 VDD.t2 VDD.n21 117.504
R9 VDD.n22 VDD.t2 47.0017
R10 VDD.n23 VDD.t0 23.5011
R11 VDD.n29 VDD.n12 23.3338
R12 VDD.n24 VDD.n10 6.5635
R13 VDD.n24 VDD.n16 23.3338
R14 VDD.n20 VDD.n16 23.3338
R15 VDD.n9 VDD.n19 11.5508
R16 VDD.n7 VDD.n17 12.8718
R17 VDD VDD.n18 15.2537
R18 VDD.n29 VDD.n28 15.0005
R19 VDD VDD.n29 15.0005
R20 VDD.n13 VDD.n12 15.0005
R21 VDD.n12 VDD.n10 6.5635
R22 VDD.n24 VDD.n23 15.0005
R23 VDD VDD.n10 4.21975
R24 VDD.n22 VDD.n16 15.0005
R25 VDD.n16 VDD 15.0005
R26 VDD.n21 VDD.n20 15.0005
R27 VDD.n20 VDD.n9 6.5635
R28 VDD VDD.n9 4.21975
R29 VDD.n11 VDD 15.0005
R30 VDD.n5 VDD.n6 4.42249
R31 VDD.n8 VDD.n6 5.29026
R32 VDD.n28 VDD.n14 15.0005
R33 VDD VDD.n7 4.34708
R34 VDD.n1 VDD.n0 5.07653
R35 VDD.n4 VDD.n1 4.84994
R36 VDD.n4 VDD.n2 5.001
R37 VDD VDD.n2 5.001
R38 VDD.n19 VDD.n2 9.98825
R39 VDD.n29 VDD.n11 14.7401
R40 VDD.n1 VDD.n7 11.1583
R41 VDD.n26 VDD.n15 12.7814
R42 VDD.n15 VDD.n6 10.6714
R43 VDD.n25 VDD 7.85998
R44 VDD VDD.n3 7.85772
R45 VDD.n26 VDD.n14 6.64275
R46 VDD.n18 VDD.n17 6.5635
R47 VDD.n28 VDD.n27 5.21839
R48 VDD.n19 VDD.n0 5.00762
R49 VDD.n27 VDD.n11 4.56622
R50 VDD.n27 VDD.n5 4.56622
R51 VDD.n8 VDD.n26 4.52391
R52 VDD.n28 VDD.n15 4.37679
R53 VDD.n17 VDD.n0 4.21975
R54 VDD.n25 VDD.t1 3.03552
R55 VDD.n3 VDD.t3 3.03552
R56 VDD.n4 VDD.n3 2.77131
R57 VDD.n5 VDD.n25 2.6876
R58 VDD.n8 VDD 1.98705
R59 VSS.n15 VSS.n12 453.695
R60 VSS.n23 VSS.n8 452.736
R61 VSS.n18 VSS.n12 452.736
R62 VSS.t0 VSS.n8 254.665
R63 VSS.n18 VSS.t0 198.072
R64 VSS.n17 VSS.n5 23.3338
R65 VSS.n17 VSS.n13 23.3338
R66 VSS.n4 VSS.n19 6.5635
R67 VSS.n19 VSS.n11 23.3338
R68 VSS.n22 VSS.n6 22.3675
R69 VSS.n25 VSS.n1 20.9317
R70 VSS.n16 VSS.n15 19.7293
R71 VSS.n15 VSS.n14 19.7293
R72 VSS.n5 VSS.n7 15.8338
R73 VSS.n21 VSS.n20 15.8338
R74 VSS VSS.n25 15.0005
R75 VSS.n7 VSS 15.0005
R76 VSS.n23 VSS.n22 15.0005
R77 VSS.n3 VSS 3.01553
R78 VSS.n23 VSS.n1 15.0005
R79 VSS.n1 VSS 15.0005
R80 VSS VSS.n21 15.0005
R81 VSS VSS.n6 15.0005
R82 VSS.n12 VSS.n11 15.0005
R83 VSS.n19 VSS.n18 15.0005
R84 VSS.n4 VSS.n0 4.21975
R85 VSS.n20 VSS.n8 15.0005
R86 VSS.n20 VSS.n4 6.5635
R87 VSS.n5 VSS.n8 15.0005
R88 VSS VSS.n5 15.0005
R89 VSS.n18 VSS.n17 15.0005
R90 VSS.n17 VSS 15.0005
R91 VSS.n13 VSS.n12 15.0005
R92 VSS.n22 VSS.n3 5.95742
R93 VSS.n2 VSS.t1 10.5005
R94 VSS.n3 VSS.n2 2.97921
R95 VSS.n2 VSS.n10 6.6005
R96 VSS.n24 VSS.n7 6.5635
R97 VSS.n6 VSS.n9 6.5635
R98 VSS.n21 VSS.n9 6.5635
R99 VSS.n25 VSS.n24 6.5635
R100 VSS.n14 VSS.n11 6.53249
R101 VSS.n16 VSS.n13 6.53249
R102 VSS.n2 VSS.n1 5.87219
R103 VSS VSS.n16 4.52391
R104 VSS.n14 VSS.n0 4.52391
R105 VSS.n24 VSS.n23 4.21975
R106 VSS.n23 VSS.n9 4.21975
R107 VSS VSS.n0 1.16544
C0 a_93_147# Y 0.21481f
C1 a_93_147# VDD 0.43523f
C2 VDD Y 0.30244f
C3 Y VSS 0.54352f
C4 VDD VSS 2.29704f
C5 VDD.n0 VSS 0.10485f
C6 VDD.t3 VSS 0.34677f
C7 VDD.n28 VSS 0.10485f
C8 Y.t1 VSS 0.38228f
.ends
