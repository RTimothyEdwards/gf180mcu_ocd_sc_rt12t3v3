* NGSPICE file created from gf180mcu_ocd_sc_rt12t3v3__buf_1.ext - technology: gf180mcuD

.subckt gf180mcu_ocd_sc_rt12t3v3__buf_1 A Y VDD VSS
X0 VDD.t3 A.t1 a_193_203r# VDD.t2 pfet_03v3 ad=0.3341p pd=1.805u as=0.3341p ps=1.805u w=1.285u l=0.28u
X1 Y.t0 a_193_203r# VSS.t3 VSS.t2 nfet_03v3 ad=0.3087p pd=2.01u as=2.92382p ps=15.475u w=1.02u l=0.28u
X2 Y.t2 a_193_203r# VDD.t5 VDD.t4 pfet_03v3 ad=0.3341p pd=1.805u as=0.3341p ps=1.805u w=1.285u l=0.28u
X3 a_193_203r# A.t2 VDD.t1 VDD.t0 pfet_03v3 ad=0.3341p pd=1.805u as=0.5654p ps=3.45u w=1.285u l=0.28u
X4 VDD.t7 a_193_203r# Y.t1 VDD.t6 pfet_03v3 ad=0.5654p pd=3.45u as=0.3341p ps=1.805u w=1.285u l=0.28u
X5 a_193_203r# A.t0 VSS.t1 VSS.t0 nfet_03v3 ad=0.3087p pd=2.01u as=2.92382p ps=15.475u w=1.02u l=0.28u
R0 Y.n7 Y.t0 120.001
R1 Y.n1 Y.n6 115.718
R2 Y.n9 Y.n8 67.4693
R3 Y.n8 Y.n7 34.8011
R4 Y.n7 Y.n6 20.0898
R5 Y Y.n0 15.2445
R6 Y.n0 Y.n1 5.1751
R7 Y.n4 Y.n1 2.89242
R8 Y Y.n5 7.94732
R9 Y.n4 Y.n3 1.97827
R10 Y.n8 Y.n2 7.5005
R11 Y.n9 Y.n6 4.52242
R12 Y.n3 Y.t0 1.09191
R13 Y.n3 Y.n2 1.96464
R14 Y.n5 Y.t2 3.03552
R15 Y.n5 Y.t1 3.03552
R16 Y.n0 Y.t0 14.0052
R17 Y.n0 Y.n2 4.18614
R18 Y.n4 Y.n9 1.72383
R19 A.n0 A.t1 82.5005
R20 A.n0 A.t2 39.6434
R21 A A.n0 18.7416
R22 A A.t0 14.1269
R23 VDD.n32 VDD.n31 292.159
R24 VDD.n34 VDD.n33 164.505
R25 VDD.n24 VDD.n22 164.505
R26 VDD.n26 VDD.n21 164.505
R27 VDD.n30 VDD.n16 164.505
R28 VDD.n34 VDD.t0 141.005
R29 VDD.t6 VDD.n16 141.005
R30 VDD.n25 VDD.t2 117.504
R31 VDD.t4 VDD.n25 117.504
R32 VDD.t2 VDD.n24 47.0017
R33 VDD.n26 VDD.t4 47.0017
R34 VDD.n22 VDD.t0 23.5011
R35 VDD.n21 VDD.t6 23.5011
R36 VDD.n36 VDD.n35 23.3338
R37 VDD.n35 VDD.n6 6.5635
R38 VDD.n23 VDD.n8 23.3338
R39 VDD.n4 VDD.n20 6.5635
R40 VDD.n27 VDD.n20 23.3338
R41 VDD.n27 VDD.n18 23.3338
R42 VDD.n5 VDD.n18 6.5635
R43 VDD.n29 VDD.n28 23.3338
R44 VDD.n13 VDD.n10 23.3338
R45 VDD.n12 VDD.n11 23.3338
R46 VDD.n3 VDD.n17 11.7458
R47 VDD VDD.n36 15.0005
R48 VDD.n35 VDD.n34 15.0005
R49 VDD.n6 VDD 4.21975
R50 VDD.n22 VDD.n8 15.0005
R51 VDD.n6 VDD.n8 6.5635
R52 VDD.n24 VDD.n23 15.0005
R53 VDD.n23 VDD.n4 6.5635
R54 VDD.n25 VDD.n20 15.0005
R55 VDD.n4 VDD.n1 4.21975
R56 VDD.n27 VDD.n26 15.0005
R57 VDD.n1 VDD.n27 15.0005
R58 VDD.n21 VDD.n18 15.0005
R59 VDD.n1 VDD.n5 4.21975
R60 VDD.n28 VDD.n16 15.0005
R61 VDD.n28 VDD.n5 6.5635
R62 VDD.n30 VDD.n29 15.0005
R63 VDD.n29 VDD.n3 5.18282
R64 VDD.n31 VDD.n30 15.0005
R65 VDD.n1 VDD.n2 4.21975
R66 VDD.n3 VDD.n1 4.91009
R67 VDD.n11 VDD 15.0005
R68 VDD VDD.n12 15.0005
R69 VDD VDD.n13 15.0005
R70 VDD.n33 VDD.n10 15.0005
R71 VDD.n33 VDD.n32 15.0005
R72 VDD.n15 VDD.n0 13.0955
R73 VDD VDD.t1 10.895
R74 VDD.n1 VDD.t7 10.8927
R75 VDD.n1 VDD.n19 7.85998
R76 VDD.n32 VDD.n14 6.64275
R77 VDD.n31 VDD.n0 6.64275
R78 VDD.n2 VDD.n15 13.1265
R79 VDD.n2 VDD.n17 13.1265
R80 VDD.n13 VDD.n9 6.5635
R81 VDD.n12 VDD.n9 6.5635
R82 VDD.n14 VDD.n10 6.53249
R83 VDD.n11 VDD.n7 5.18282
R84 VDD.n36 VDD.n7 5.18282
R85 VDD.n33 VDD.n7 4.91009
R86 VDD.n1 VDD.n0 4.52391
R87 VDD.n14 VDD 4.52391
R88 VDD.n30 VDD.n15 4.21975
R89 VDD.n30 VDD.n17 4.21975
R90 VDD.n33 VDD.n9 4.21975
R91 VDD.n19 VDD.t3 3.03552
R92 VDD.n19 VDD.t5 3.03552
R93 VDD.n1 VDD 2.02503
R94 VSS.n34 VSS.n33 513.399
R95 VSS.n20 VSS.n19 513.399
R96 VSS.n20 VSS.n18 513.399
R97 VSS.n24 VSS.n23 513.399
R98 VSS.n25 VSS.n24 513.399
R99 VSS.n25 VSS.n14 513.399
R100 VSS.n18 VSS.t2 472.144
R101 VSS.n31 VSS.n30 319.659
R102 VSS.n34 VSS.t0 316.291
R103 VSS.n19 VSS.t0 197.109
R104 VSS.n23 VSS.t2 41.2558
R105 VSS.n35 VSS.n13 23.3338
R106 VSS.n10 VSS.n9 6.51263
R107 VSS.n21 VSS.n16 22.3675
R108 VSS.n11 VSS.n16 6.32546
R109 VSS.n26 VSS.n12 21.306
R110 VSS.n35 VSS.n3 20.9317
R111 VSS.n8 VSS.n13 15.8338
R112 VSS.n27 VSS.n9 15.6255
R113 VSS VSS.n31 15.2537
R114 VSS.n30 VSS 15.2537
R115 VSS.n35 VSS.n34 15.0005
R116 VSS VSS.n35 15.0005
R117 VSS.n33 VSS.n13 15.0005
R118 VSS.n13 VSS 15.0005
R119 VSS.n21 VSS.n20 15.0005
R120 VSS VSS.n2 3.01553
R121 VSS.n19 VSS.n3 15.0005
R122 VSS.n3 VSS 15.0005
R123 VSS.n18 VSS.n16 15.0005
R124 VSS VSS.n11 4.33877
R125 VSS.n24 VSS.n12 15.0005
R126 VSS VSS.n1 3.6097
R127 VSS.n23 VSS.n22 15.0005
R128 VSS.n22 VSS.n11 6.32546
R129 VSS.n9 VSS.n14 15.0005
R130 VSS VSS.n10 4.24519
R131 VSS.n26 VSS.n25 15.0005
R132 VSS.n10 VSS.n26 6.51263
R133 VSS.n7 VSS 4.21975
R134 VSS.n28 VSS.n7 13.1265
R135 VSS.n27 VSS 15.0005
R136 VSS VSS.n8 15.0005
R137 VSS VSS.n6 4.21975
R138 VSS.n21 VSS.n2 5.95742
R139 VSS.n22 VSS.n0 11.5668
R140 VSS.n0 VSS.t3 10.5005
R141 VSS.n4 VSS.t1 10.5005
R142 VSS.n1 VSS.n12 4.17491
R143 VSS.n4 VSS.n2 2.97921
R144 VSS.n1 VSS.n0 2.08796
R145 VSS.n4 VSS.n17 6.6005
R146 VSS.n31 VSS.n5 6.5635
R147 VSS.n30 VSS.n29 6.5635
R148 VSS.n32 VSS.n8 6.5635
R149 VSS.n32 VSS.n6 13.1265
R150 VSS.n6 VSS.n5 13.1265
R151 VSS.n28 VSS.n27 6.5635
R152 VSS.n29 VSS.n7 13.1265
R153 VSS.n0 VSS.n15 7.0505
R154 VSS.n4 VSS.n3 5.87219
R155 VSS.n29 VSS.n14 4.21975
R156 VSS.n28 VSS.n14 4.21975
R157 VSS.n33 VSS.n32 4.21975
R158 VSS.n33 VSS.n5 4.21975
C0 Y VDD 0.30652f
C1 a_193_203r# VDD 0.59029f
C2 a_193_203r# A 0.29821f
C3 VDD A 0.44406f
C4 a_193_203r# Y 0.28905f
C5 Y VSS 0.49554f
C6 A VSS 0.91756f
C7 VDD VSS 3.15042f
C8 a_193_203r# VSS 0.12117f
C9 VSS.t3 VSS 0.29965f
C10 VSS.t1 VSS 0.12117f
C11 VDD.n1 VSS 0.12435f
C12 VDD.n30 VSS 0.13972f
C13 VDD.n33 VSS 0.14365f
C14 Y.t0 VSS 0.3097f
.ends
