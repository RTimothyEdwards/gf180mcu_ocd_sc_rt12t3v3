* NGSPICE file created from gf180mcu_ocd_sc_rt12t3v3__inv_4.ext - technology: gf180mcuD

.subckt gf180mcu_ocd_sc_rt12t3v3__inv_4 A Y VDD VSS
X0 Y.t1 A.t1 VSS.t5 VSS.t4 nfet_03v3 ad=0.3087p pd=2.01u as=4.2213p ps=21.07u w=1.02u l=0.28u
X1 VDD.t11 A.t4 Y.t9 VDD.t10 pfet_03v3 ad=0.8721p pd=4.44u as=0.4446p ps=2.23u w=1.71u l=0.28u
X2 Y.t7 A.t7 VDD.t5 VDD.t4 pfet_03v3 ad=0.4446p pd=2.23u as=0.4446p ps=2.23u w=1.71u l=0.28u
X3 Y.t5 A.t0 VSS.t7 VSS.t6 nfet_03v3 ad=0.3087p pd=2.01u as=4.2213p ps=21.07u w=1.02u l=0.28u
X4 Y.t8 A.t9 VDD.t1 VDD.t0 pfet_03v3 ad=0.4446p pd=2.23u as=0.7524p ps=4.3u w=1.71u l=0.28u
X5 VDD.t7 A.t6 Y.t2 VDD.t6 pfet_03v3 ad=0.4446p pd=2.23u as=0.4446p ps=2.23u w=1.71u l=0.28u
X6 Y.t4 A.t3 VSS.t1 VSS.t0 nfet_03v3 ad=0.3087p pd=2.01u as=4.2213p ps=21.07u w=1.02u l=0.28u
X7 VDD.t3 A.t8 Y.t6 VDD.t2 pfet_03v3 ad=0.4446p pd=2.23u as=0.4446p ps=2.23u w=1.71u l=0.28u
X8 Y.t0 A.t5 VDD.t9 VDD.t8 pfet_03v3 ad=0.4446p pd=2.23u as=0.4446p ps=2.23u w=1.71u l=0.28u
X9 Y.t3 A.t2 VSS.t3 VSS.t2 nfet_03v3 ad=0.3087p pd=2.01u as=4.2213p ps=21.07u w=1.02u l=0.28u
R0 Y.n35 Y.t5 120.001
R1 Y.n31 Y.t1 120.001
R2 Y.n27 Y.t3 120.001
R3 Y.n23 Y.t4 120.001
R4 Y.n6 Y.n34 115.718
R5 Y.n10 Y.n30 115.718
R6 Y.n14 Y.n26 115.718
R7 Y.n18 Y.n22 115.718
R8 Y.n37 Y.n36 67.4693
R9 Y.n33 Y.n32 67.4693
R10 Y.n29 Y.n28 67.4693
R11 Y.n25 Y.n24 67.4693
R12 Y.n36 Y.n35 40.8056
R13 Y.n32 Y.n31 40.8056
R14 Y.n28 Y.n27 40.8056
R15 Y.n24 Y.n23 34.8011
R16 Y.n35 Y.n34 20.0898
R17 Y.n31 Y.n30 20.0898
R18 Y.n27 Y.n26 20.0898
R19 Y.n23 Y.n22 20.0898
R20 Y.n1 Y.n5 15.6562
R21 Y.n1 Y.n4 15.0005
R22 Y.n1 Y.n3 15.0005
R23 Y Y.n2 15.0005
R24 Y.n2 Y.n6 5.1751
R25 Y.n3 Y.n10 5.1751
R26 Y.n4 Y.n14 5.1751
R27 Y.n5 Y.n18 5.1751
R28 Y.n9 Y.n6 2.89242
R29 Y.n13 Y.n10 2.89242
R30 Y.n17 Y.n14 2.89242
R31 Y.n21 Y.n18 2.89242
R32 Y.n9 Y.n8 1.97827
R33 Y.n36 Y.n7 7.5005
R34 Y.n13 Y.n12 1.97827
R35 Y.n32 Y.n11 7.5005
R36 Y.n17 Y.n16 1.97827
R37 Y.n28 Y.n15 7.5005
R38 Y.n21 Y.n20 1.97827
R39 Y.n24 Y.n19 7.5005
R40 Y.n0 Y.n40 5.9772
R41 Y.n0 Y.n39 5.25824
R42 Y.n0 Y.n38 5.25598
R43 Y.n37 Y.n34 4.52242
R44 Y.n33 Y.n30 4.52242
R45 Y.n29 Y.n26 4.52242
R46 Y.n25 Y.n22 4.52242
R47 Y.n8 Y.t5 1.09191
R48 Y.n12 Y.t1 1.09191
R49 Y.n16 Y.t3 1.09191
R50 Y.n20 Y.t4 1.09191
R51 Y.n8 Y.n7 1.96464
R52 Y.n12 Y.n11 1.96464
R53 Y.n16 Y.n15 1.96464
R54 Y.n20 Y.n19 1.96464
R55 Y.n40 Y.t8 2.2812
R56 Y.n40 Y.t6 2.2812
R57 Y.n39 Y.t7 2.2812
R58 Y.n39 Y.t2 2.2812
R59 Y.n38 Y.t0 2.2812
R60 Y.n38 Y.t9 2.2812
R61 Y.n2 Y.t5 14.0052
R62 Y.n3 Y.t1 14.0052
R63 Y.n4 Y.t3 14.0052
R64 Y.n5 Y.t4 14.0052
R65 Y.n5 Y.n19 4.18614
R66 Y.n4 Y.n15 4.18614
R67 Y.n3 Y.n11 4.18614
R68 Y.n2 Y.n7 4.18614
R69 Y Y.n0 2.7045
R70 Y.n21 Y.n25 1.72383
R71 Y.n17 Y.n29 1.72383
R72 Y.n13 Y.n33 1.72383
R73 Y.n9 Y.n37 1.72383
R74 Y Y.n1 1.54015
R75 A.n18 A.n0 128.697
R76 A.n13 A.t9 84.4945
R77 A.n11 A.t4 84.4945
R78 A.n1 A.n17 71.2411
R79 A.n22 A.n16 69.1799
R80 A.n13 A.t8 51.1612
R81 A.n14 A.t7 51.1612
R82 A.n12 A.t6 51.1612
R83 A.n11 A.t5 51.1612
R84 A.n22 A.n21 42.5409
R85 A.n21 A.n17 42.5409
R86 A.n14 A.n13 33.3338
R87 A.n12 A.n11 33.3338
R88 A.n24 A.n16 28.0946
R89 A.n20 A.n5 27.6834
R90 A.n25 A.n2 8.0676
R91 A.n6 A.n5 16.8788
R92 A.n15 A.n14 16.8755
R93 A.n15 A.n12 16.4588
R94 A.n18 A.n1 15.3414
R95 A.n5 A.n10 5.4065
R96 A.n10 A.t1 1.61396
R97 A.n25 A.t2 12.0226
R98 A.n19 A.n0 17.7136
R99 A.n24 A.n23 11.5184
R100 A.n6 A.n4 10.9301
R101 A.n10 A.n9 12.6731
R102 A.n9 A.n18 9.19464
R103 A.t0 A.n1 8.16552
R104 A.n7 A.n6 2.51769
R105 A.n9 A.n8 2.51798
R106 A.t1 A.n8 10.9009
R107 A.n3 A.t3 0.842757
R108 A.n7 A.t2 10.901
R109 A.n26 A.n25 7.41985
R110 A.t0 A.n0 0.34638
R111 A.n23 A.n2 6.94892
R112 A.n26 A.n4 5.56885
R113 A.t3 A.n24 4.01836
R114 A.t2 A.n4 3.87592
R115 A.n2 A.n3 3.26815
R116 A A.n15 2.92647
R117 A A.n26 2.70268
R118 A.n19 A.n17 2.41122
R119 A.n21 A.n20 2.41122
R120 A.n23 A.n22 2.41122
R121 A.n3 A.n16 5.3203
R122 A.n19 A.n8 6.39929
R123 A.n7 A.n20 6.39919
R124 VDD.n42 VDD.n41 444.887
R125 VDD.n44 VDD.n43 164.505
R126 VDD.n29 VDD.n27 164.505
R127 VDD.n31 VDD.n26 164.505
R128 VDD.t10 VDD.n35 164.505
R129 VDD.t10 VDD.n21 164.505
R130 VDD.n21 VDD.n18 164.505
R131 VDD.n40 VDD.n18 164.505
R132 VDD.n44 VDD.t0 141.005
R133 VDD.n34 VDD.t6 141.005
R134 VDD.n30 VDD.t2 117.504
R135 VDD.t4 VDD.n30 117.504
R136 VDD.t8 VDD.n34 94.0029
R137 VDD.n35 VDD.t8 70.5023
R138 VDD.t2 VDD.n29 47.0017
R139 VDD.n31 VDD.t4 47.0017
R140 VDD.n27 VDD.t0 23.5011
R141 VDD.n26 VDD.t6 23.5011
R142 VDD.n2 VDD.n17 13.1265
R143 VDD.n46 VDD.n45 23.3338
R144 VDD.n45 VDD.n6 6.5635
R145 VDD.n28 VDD.n10 23.3338
R146 VDD.n3 VDD.n25 6.5635
R147 VDD.n32 VDD.n25 23.3338
R148 VDD.n32 VDD.n22 23.3338
R149 VDD.n5 VDD.n22 6.5635
R150 VDD.n33 VDD.n20 23.3338
R151 VDD.n36 VDD.n20 23.3338
R152 VDD.n36 VDD.n7 6.5635
R153 VDD.n37 VDD.n8 23.3338
R154 VDD.n4 VDD.n37 6.5635
R155 VDD.n15 VDD.n12 23.3338
R156 VDD.n14 VDD.n13 23.3338
R157 VDD.n39 VDD.n38 15.8338
R158 VDD VDD.n46 15.0005
R159 VDD.n45 VDD.n44 15.0005
R160 VDD.n6 VDD 4.21975
R161 VDD.n27 VDD.n10 15.0005
R162 VDD.n6 VDD.n10 6.5635
R163 VDD.n29 VDD.n28 15.0005
R164 VDD.n28 VDD.n3 6.5635
R165 VDD.n30 VDD.n25 15.0005
R166 VDD.n3 VDD 4.21975
R167 VDD.n32 VDD.n31 15.0005
R168 VDD VDD.n32 15.0005
R169 VDD.n26 VDD.n22 15.0005
R170 VDD VDD.n5 4.21975
R171 VDD.n34 VDD.n33 15.0005
R172 VDD.n33 VDD.n5 6.5635
R173 VDD.n35 VDD.n20 15.0005
R174 VDD.n20 VDD.n0 15.0005
R175 VDD.n36 VDD.t10 15.0005
R176 VDD.n0 VDD.n7 4.21975
R177 VDD.n21 VDD.n8 15.0005
R178 VDD.n7 VDD.n8 6.5635
R179 VDD.n37 VDD.n18 15.0005
R180 VDD.n4 VDD.n0 4.21975
R181 VDD.n40 VDD.n39 15.0005
R182 VDD.n39 VDD.n4 6.5635
R183 VDD.n41 VDD.n40 15.0005
R184 VDD.n2 VDD.n0 4.21975
R185 VDD.n38 VDD.n0 15.0005
R186 VDD.n13 VDD 15.0005
R187 VDD VDD.n14 15.0005
R188 VDD VDD.n15 15.0005
R189 VDD.n43 VDD.n12 15.0005
R190 VDD.n43 VDD.n42 15.0005
R191 VDD.n17 VDD.n1 13.0955
R192 VDD.n0 VDD.t11 10.1452
R193 VDD VDD.n24 7.8645
R194 VDD VDD.n23 7.86224
R195 VDD VDD.t1 7.7492
R196 VDD.n42 VDD.n16 6.64275
R197 VDD.n41 VDD.n1 6.64275
R198 VDD.n38 VDD.n19 6.5635
R199 VDD.n2 VDD.n19 13.1265
R200 VDD.n15 VDD.n11 6.5635
R201 VDD.n14 VDD.n11 6.5635
R202 VDD.n16 VDD.n12 6.53249
R203 VDD.n13 VDD.n9 5.18282
R204 VDD.n46 VDD.n9 5.18282
R205 VDD.n43 VDD.n9 4.91009
R206 VDD.n0 VDD.n1 4.52391
R207 VDD.n16 VDD 4.52391
R208 VDD.n40 VDD.n17 4.21975
R209 VDD.n40 VDD.n19 4.21975
R210 VDD.n43 VDD.n11 4.21975
R211 VDD VDD.n0 2.4133
R212 VDD.n23 VDD.t7 2.2812
R213 VDD.n23 VDD.t9 2.2812
R214 VDD.n24 VDD.t3 2.2812
R215 VDD.n24 VDD.t5 2.2812
R216 VSS.n47 VSS.n46 513.399
R217 VSS.n28 VSS.n27 513.399
R218 VSS.n29 VSS.n28 513.399
R219 VSS.n33 VSS.n32 513.399
R220 VSS.n34 VSS.n21 513.399
R221 VSS.n37 VSS.n21 513.399
R222 VSS.n39 VSS.n38 513.399
R223 VSS.n39 VSS.n19 513.399
R224 VSS.n32 VSS.t2 495.063
R225 VSS.n44 VSS.n43 472.387
R226 VSS.n38 VSS.t6 403.385
R227 VSS.t4 VSS.n33 320.875
R228 VSS.n27 VSS.t0 284.204
R229 VSS.n47 VSS.t0 229.196
R230 VSS.n34 VSS.t4 192.525
R231 VSS.t6 VSS.n37 110.014
R232 VSS.n40 VSS.n20 23.3338
R233 VSS.n48 VSS.n18 23.3338
R234 VSS.n16 VSS.n2 6.31159
R235 VSS.n30 VSS.n26 21.7876
R236 VSS.n31 VSS.n17 21.0698
R237 VSS.n35 VSS.n17 20.9593
R238 VSS.n15 VSS.n0 6.09312
R239 VSS.n48 VSS.n7 20.4071
R240 VSS.n29 VSS.t2 18.3362
R241 VSS.n26 VSS.n9 6.7194
R242 VSS.n36 VSS.n1 17.5306
R243 VSS.n13 VSS.n18 15.8338
R244 VSS VSS.n44 15.2537
R245 VSS.n43 VSS 15.2537
R246 VSS.n48 VSS.n47 15.0005
R247 VSS VSS.n48 15.0005
R248 VSS.n46 VSS.n18 15.0005
R249 VSS.n18 VSS 15.0005
R250 VSS.n28 VSS.n26 15.0005
R251 VSS.n9 VSS 2.76153
R252 VSS.n27 VSS.n7 15.0005
R253 VSS.n7 VSS 15.0005
R254 VSS.n32 VSS.n31 15.0005
R255 VSS.n6 VSS 3.84383
R256 VSS.n30 VSS.n29 15.0005
R257 VSS VSS.n30 15.0005
R258 VSS.n33 VSS.n17 15.0005
R259 VSS VSS.n17 15.0005
R260 VSS.n2 VSS.n21 15.0005
R261 VSS VSS.n16 4.34571
R262 VSS.n35 VSS.n34 15.0005
R263 VSS.n4 VSS 3.94112
R264 VSS.n38 VSS.n0 15.0005
R265 VSS VSS.n15 4.45494
R266 VSS.n37 VSS.n36 15.0005
R267 VSS.n36 VSS.n16 6.31159
R268 VSS.n20 VSS.n19 15.0005
R269 VSS.n14 VSS.n20 5.18282
R270 VSS.n40 VSS.n39 15.0005
R271 VSS.n15 VSS.n40 6.09312
R272 VSS.n12 VSS 4.21975
R273 VSS.n41 VSS.n12 13.1265
R274 VSS.n14 VSS 4.91009
R275 VSS VSS.n13 15.0005
R276 VSS VSS.n11 4.21975
R277 VSS.n3 VSS.n2 14.6391
R278 VSS.n30 VSS.n5 13.9162
R279 VSS.n1 VSS.t7 10.5005
R280 VSS.n3 VSS.t5 10.5005
R281 VSS.n5 VSS.t3 10.5005
R282 VSS.n8 VSS.t1 10.5005
R283 VSS.n9 VSS.n8 3.3602
R284 VSS.n6 VSS.n5 1.73676
R285 VSS.n4 VSS.n3 1.59082
R286 VSS VSS.n1 7.5005
R287 VSS.n1 VSS.n22 6.6005
R288 VSS.n3 VSS.n23 6.6005
R289 VSS.n5 VSS.n24 6.6005
R290 VSS.n8 VSS.n25 6.6005
R291 VSS.n44 VSS.n10 6.5635
R292 VSS.n43 VSS.n42 6.5635
R293 VSS.n45 VSS.n13 6.5635
R294 VSS.n45 VSS.n11 13.1265
R295 VSS.n11 VSS.n10 13.1265
R296 VSS.n41 VSS.n14 11.7458
R297 VSS.n42 VSS.n12 13.1265
R298 VSS.n4 VSS.n35 3.18063
R299 VSS.n31 VSS.n6 3.47251
R300 VSS.n42 VSS.n19 4.21975
R301 VSS.n41 VSS.n19 4.21975
R302 VSS.n46 VSS.n45 4.21975
R303 VSS.n46 VSS.n10 4.21975
R304 VSS.n1 VSS.n0 3.16134
R305 VSS.n8 VSS.n7 2.43845
C0 A Y 1.07837f
C1 A VDD 1.31074f
C2 VDD Y 0.79976f
C3 Y VSS 0.51132f
C4 A VSS 1.98962f
C5 VDD VSS 4.36953f
C6 VDD.n0 VSS 0.1145f
C7 VDD.n40 VSS 0.15779f
C8 VDD.n43 VSS 0.15779f
C9 A.n1 VSS 0.1088f
C10 A.n16 VSS 0.15966f
C11 A.n17 VSS 0.11318f
C12 A.n22 VSS 0.11727f
C13 Y.n0 VSS 0.33895f
C14 Y.n1 VSS 0.134f
.ends
