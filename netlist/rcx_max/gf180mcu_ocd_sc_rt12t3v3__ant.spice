* NGSPICE file created from gf180mcu_ocd_sc_rt12t3v3__ant.ext - technology: gf180mcuD

.subckt gf180mcu_ocd_sc_rt12t3v3__ant A VDD VSS
R0 VDD.n12 VDD.n8 233.44
R1 VDD.n16 VDD.n8 231.725
R2 VDD.n17 VDD.n16 231.725
R3 VDD.n18 VDD.n17 231.725
R4 VDD.n18 VDD.n5 231.725
R5 VDD.n15 VDD.n9 23.3338
R6 VDD.n15 VDD.n0 23.3338
R7 VDD.n19 VDD.n0 23.3338
R8 VDD.n21 VDD.n20 23.3338
R9 VDD.n10 VDD.n7 23.3338
R10 VDD.n7 VDD.n2 6.5635
R11 VDD.n1 VDD.n4 23.3338
R12 VDD.n13 VDD.n12 18.2147
R13 VDD.n12 VDD.n11 18.2147
R14 VDD.n3 VDD.n19 5.18282
R15 VDD.n23 VDD.n4 15.8338
R16 VDD VDD.n23 15.0005
R17 VDD.n21 VDD 15.0005
R18 VDD.n20 VDD 15.0005
R19 VDD.n9 VDD.n8 15.0005
R20 VDD.n16 VDD.n15 15.0005
R21 VDD.n15 VDD.n14 15.0005
R22 VDD.n17 VDD.n0 15.0005
R23 VDD VDD.n0 15.0005
R24 VDD.n19 VDD.n18 15.0005
R25 VDD.n3 VDD 4.91009
R26 VDD.n18 VDD.n4 15.0005
R27 VDD.n4 VDD 15.0005
R28 VDD.n17 VDD.n1 15.0005
R29 VDD.n2 VDD.n1 6.5635
R30 VDD.n16 VDD.n7 15.0005
R31 VDD VDD.n2 4.21975
R32 VDD.n10 VDD.n8 15.0005
R33 VDD.n23 VDD.n22 6.5635
R34 VDD.n3 VDD.n6 11.7458
R35 VDD.n22 VDD.n21 6.5635
R36 VDD.n20 VDD.n6 6.5635
R37 VDD.n11 VDD.n10 6.53249
R38 VDD.n13 VDD.n9 6.53249
R39 VDD.n14 VDD.n13 4.52391
R40 VDD.n11 VDD 4.52391
R41 VDD.n22 VDD.n5 4.21975
R42 VDD.n6 VDD.n5 4.21975
R43 VDD.n14 VDD 1.5397
R44 VSS.n12 VSS.n10 629.005
R45 VSS.n18 VSS.n6 627.587
R46 VSS.n15 VSS.n6 627.587
R47 VSS.n15 VSS.n10 627.587
R48 VSS.n19 VSS.n5 23.3338
R49 VSS.n17 VSS.n3 6.5635
R50 VSS.n14 VSS.n4 23.3338
R51 VSS.n14 VSS.n11 23.3338
R52 VSS.n16 VSS.n1 6.5635
R53 VSS.n16 VSS.n9 23.3338
R54 VSS.n13 VSS.n12 18.8086
R55 VSS.n12 VSS.n8 18.8086
R56 VSS.n19 VSS.n4 15.8338
R57 VSS.n17 VSS.n2 15.8338
R58 VSS.n18 VSS.n17 15.0005
R59 VSS.n3 VSS.n0 4.21975
R60 VSS.n3 VSS.n7 13.1265
R61 VSS.n5 VSS 15.0005
R62 VSS.n19 VSS.n18 15.0005
R63 VSS VSS.n19 15.0005
R64 VSS.n6 VSS.n4 15.0005
R65 VSS.n4 VSS 15.0005
R66 VSS.n15 VSS.n14 15.0005
R67 VSS.n14 VSS 15.0005
R68 VSS.n11 VSS.n10 15.0005
R69 VSS.n10 VSS.n9 15.0005
R70 VSS.n16 VSS.n15 15.0005
R71 VSS.n0 VSS.n1 4.21975
R72 VSS.n2 VSS.n6 15.0005
R73 VSS.n1 VSS.n2 6.5635
R74 VSS.n7 VSS.n5 6.5635
R75 VSS.n13 VSS.n11 6.53249
R76 VSS.n9 VSS.n8 6.53249
R77 VSS.n0 VSS.n8 4.52391
R78 VSS VSS.n13 4.52391
R79 VSS.n18 VSS.n7 4.21975
R80 VSS.n0 VSS 1.03327
C0 VDD A 0.32214f
C1 A VSS 0.33895f
C2 VDD VSS 1.73701f
.ends
