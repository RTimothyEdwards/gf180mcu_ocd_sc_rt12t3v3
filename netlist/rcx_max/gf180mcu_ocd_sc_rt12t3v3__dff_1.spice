* NGSPICE file created from gf180mcu_ocd_sc_rt12t3v3__dff_1.ext - technology: gf180mcuD

.subckt gf180mcu_ocd_sc_rt12t3v3__dff_1 D CLK Q QN VDD VSS
X0 a_828_987.t0 CLKb.t7 in1.t0 VDD.t6 pfet_03v3 ad=0.5654p pd=3.45u as=0.3341p ps=1.805u w=1.285u l=0.28u
X1 out1 in1.t8 VDD.t37 VDD.t36 pfet_03v3 ad=0.3341p pd=1.805u as=0.5654p ps=3.45u w=1.285u l=0.28u
X2 a_2812_987.t3 out1 VDD.t35 VDD.t34 pfet_03v3 ad=0.3341p pd=1.805u as=0.3341p ps=1.805u w=1.285u l=0.28u
X3 a_4028_987.t1 out2.t7 VDD.t15 VDD.t14 pfet_03v3 ad=0.3341p pd=1.805u as=0.3341p ps=1.805u w=1.285u l=0.28u
X4 CLKN CLK.t2 VDD.t41 VDD.t40 pfet_03v3 ad=0.3341p pd=1.805u as=19.0728p ps=0.12486m w=1.285u l=0.28u
X5 VDD.t21 CLKN CLKb.t2 VDD.t20 pfet_03v3 ad=0.5654p pd=3.45u as=0.3341p ps=1.805u w=1.285u l=0.28u
X6 VDD.t45 D.t2 a_828_987.t2 VDD.t44 pfet_03v3 ad=0.3341p pd=1.805u as=0.5654p ps=3.45u w=1.285u l=0.28u
X7 out2.t1 in2.t7 VDD.t3 VDD.t2 pfet_03v3 ad=0.5654p pd=3.45u as=0.3341p ps=1.805u w=1.285u l=0.28u
X8 in1.t1 CLKN a_945_203r# VSS.t12 nfet_03v3 ad=0.3087p pd=2.01u as=0.52065p ps=3.23u w=1.02u l=0.28u
X9 VDD.t31 out1 a_2044_987.t2 VDD.t30 pfet_03v3 ad=0.3341p pd=1.805u as=0.5654p ps=3.45u w=1.285u l=0.28u
X10 a_2044_987.t0 CLKN in1.t3 VDD.t25 pfet_03v3 ad=0.5654p pd=3.45u as=0.3341p ps=1.805u w=1.285u l=0.28u
X11 VDD.t29 out1 a_2812_987.t2 VDD.t28 pfet_03v3 ad=0.3341p pd=1.805u as=0.5654p ps=3.45u w=1.285u l=0.28u
X12 Q.t0 QN.t5 VDD.t11 VDD.t10 pfet_03v3 ad=0.3341p pd=1.805u as=0.3341p ps=1.805u w=1.285u l=0.28u
X13 QN.t1 out2.t3 VSS.t9 VSS.t8 nfet_03v3 ad=0.3087p pd=2.01u as=2.74232p ps=14.88u w=1.02u l=0.28u
X14 a_2044_987.t3 out1 VDD.t33 VDD.t32 pfet_03v3 ad=0.3341p pd=1.805u as=0.3341p ps=1.805u w=1.285u l=0.28u
X15 in2.t4 CLKb.t3 a_2903_203r# VSS.t18 nfet_03v3 ad=0.3087p pd=2.01u as=0.52065p ps=3.23u w=1.02u l=0.28u
X16 Q.t1 QN.t3 VSS.t7 VSS.t6 nfet_03v3 ad=0.3087p pd=2.01u as=3.08512p ps=16.74u w=1.02u l=0.28u
X17 a_2135_203r# out1 VSS.t15 VSS.t14 nfet_03v3 ad=0.3087p pd=2.01u as=2.74232p ps=14.88u w=1.02u l=0.28u
X18 a_2903_203r# out1 VSS.t17 VSS.t16 nfet_03v3 ad=0.3087p pd=2.01u as=2.74232p ps=14.88u w=1.02u l=0.28u
X19 a_828_987.t3 D.t1 VDD.t47 VDD.t46 pfet_03v3 ad=0.3341p pd=1.805u as=0.3341p ps=1.805u w=1.285u l=0.28u
X20 CLKN CLK.t0 VSS.t20 VSS.t19 nfet_03v3 ad=0.3087p pd=2.01u as=3.08512p ps=16.74u w=1.02u l=0.28u
X21 out1 in1.t6 VSS.t3 VSS.t2 nfet_03v3 ad=0.3087p pd=2.015u as=3.08512p ps=16.74u w=1.02u l=0.28u
X22 VDD.t5 in1.t7 out1 VDD.t4 pfet_03v3 ad=0.5654p pd=3.45u as=0.3341p ps=1.805u w=1.285u l=0.28u
X23 VDD.t13 QN.t4 Q.t2 VDD.t12 pfet_03v3 ad=0.5654p pd=3.45u as=0.3341p ps=1.805u w=1.285u l=0.28u
X24 in2.t5 CLKb.t6 a_4028_987.t3 VDD.t39 pfet_03v3 ad=0.3341p pd=1.805u as=0.3341p ps=1.805u w=1.285u l=0.28u
X25 in2.t2 CLKN a_2812_987.t1 VDD.t26 pfet_03v3 ad=0.3341p pd=1.805u as=0.3341p ps=1.805u w=1.285u l=0.28u
X26 VDD.t43 CLK.t1 CLKN VDD.t42 pfet_03v3 ad=0.3341p pd=1.805u as=0.3341p ps=1.805u w=1.285u l=0.28u
X27 in1.t5 CLKb.t4 a_2135_203r# VSS.t21 nfet_03v3 ad=0.3087p pd=2.01u as=0.52065p ps=3.23u w=1.02u l=0.28u
X28 a_4028_987.t0 CLKb.t5 in2.t0 VDD.t9 pfet_03v3 ad=0.5654p pd=3.45u as=0.3341p ps=1.805u w=1.285u l=0.28u
X29 a_2812_987.t0 CLKN in2.t3 VDD.t27 pfet_03v3 ad=0.5654p pd=3.45u as=0.3341p ps=1.805u w=1.285u l=0.28u
X30 QN.t2 out2.t6 VDD.t17 VDD.t16 pfet_03v3 ad=0.3341p pd=1.805u as=0.5654p ps=3.45u w=1.285u l=0.28u
X31 CLKb.t1 CLKN VDD.t23 VDD.t22 pfet_03v3 ad=0.3341p pd=1.805u as=0.3341p ps=1.805u w=1.285u l=0.28u
X32 CLKb.t0 CLKN VSS.t11 VSS.t10 nfet_03v3 ad=0.3087p pd=2.01u as=3.08512p ps=16.74u w=1.02u l=0.28u
X33 VDD.t1 in2.t8 out2.t0 VDD.t0 pfet_03v3 ad=0.3341p pd=1.805u as=0.5654p ps=3.45u w=1.285u l=0.28u
X34 in1.t2 CLKN a_2044_987.t1 VDD.t24 pfet_03v3 ad=0.3341p pd=1.805u as=0.3341p ps=1.805u w=1.285u l=0.28u
X35 in1.t4 CLKb.t8 a_828_987.t1 VDD.t38 pfet_03v3 ad=0.3341p pd=1.805u as=0.3341p ps=1.805u w=1.285u l=0.28u
X36 VDD.t8 out2.t5 QN.t0 VDD.t7 pfet_03v3 ad=0.3341p pd=1.805u as=0.3341p ps=1.805u w=1.285u l=0.28u
X37 in2.t1 CLKN a_4107_203r# VSS.t13 nfet_03v3 ad=0.3087p pd=2.01u as=0.53235p ps=3.25u w=1.02u l=0.28u
X38 a_945_203r# D.t0 VSS.t23 VSS.t22 nfet_03v3 ad=0.3087p pd=2.01u as=3.08512p ps=16.74u w=1.02u l=0.28u
X39 VDD.t19 out2.t8 a_4028_987.t2 VDD.t18 pfet_03v3 ad=0.3341p pd=1.805u as=0.5654p ps=3.45u w=1.285u l=0.28u
X40 out2.t2 in2.t6 VSS.t5 VSS.t4 nfet_03v3 ad=0.3087p pd=2.015u as=3.08512p ps=16.74u w=1.02u l=0.28u
X41 a_4107_203r# out2.t4 VSS.t1 VSS.t0 nfet_03v3 ad=0.3087p pd=2.01u as=2.74232p ps=14.88u w=1.02u l=0.28u
R0 Q.n7 Q.t1 120.001
R1 Q.n1 Q.n6 115.718
R2 Q.n9 Q.n8 67.4693
R3 Q.n8 Q.n7 34.8011
R4 Q.n7 Q.n6 20.0898
R5 Q Q.n0 15.3213
R6 Q.n0 Q.n1 5.1751
R7 Q.n4 Q.n1 2.89242
R8 Q Q.n5 7.87949
R9 Q.n4 Q.n3 1.97827
R10 Q.n8 Q.n2 7.5005
R11 Q.n9 Q.n6 4.52242
R12 Q.n3 Q.t1 1.09191
R13 Q.n3 Q.n2 1.96464
R14 Q.n5 Q.t0 3.03552
R15 Q.n5 Q.t2 3.03552
R16 Q.n0 Q.t1 14.0052
R17 Q.n0 Q.n2 4.18614
R18 Q.n4 Q.n9 1.72383
R19 QN.n8 QN.t1 120.001
R20 QN.n1 QN.n7 115.718
R21 QN.n6 QN.t4 85.7743
R22 QN.n6 QN.t5 78.2743
R23 QN.n10 QN.n9 67.4693
R24 QN.n9 QN.n8 34.8011
R25 QN.n8 QN.n7 20.0898
R26 QN QN.n0 15.4443
R27 QN.n0 QN.n1 5.1751
R28 QN.n4 QN.n1 2.89242
R29 QN QN.n5 7.88133
R30 QN QN.n6 7.76276
R31 QN.n4 QN.n3 1.97827
R32 QN.n9 QN.n2 7.5005
R33 QN QN.t3 12.6231
R34 QN.n10 QN.n7 4.52242
R35 QN.n3 QN.t1 1.09191
R36 QN.n3 QN.n2 1.96464
R37 QN.n5 QN.t2 3.03552
R38 QN.n5 QN.t0 3.03552
R39 QN.n0 QN.t1 14.0052
R40 QN.n0 QN.n2 4.18614
R41 QN.n4 QN.n10 1.72383
R42 D.n0 D.t1 64.435
R43 D.n0 D.t2 48.185
R44 D D.n0 38.4976
R45 D D.t0 13.3928
R46 CLK.n0 CLK.t1 82.5005
R47 CLK.n0 CLK.t2 39.6434
R48 CLK CLK.n0 30.5343
R49 CLK CLK.t0 13.4212
R50 VDD.n135 VDD.n134 1895.8
R51 VDD.n140 VDD.n36 164.505
R52 VDD.t42 VDD.n76 164.505
R53 VDD.t42 VDD.n75 164.505
R54 VDD.n81 VDD.n80 164.505
R55 VDD.n81 VDD.n72 164.505
R56 VDD.n86 VDD.n85 164.505
R57 VDD.n90 VDD.n89 164.505
R58 VDD.n91 VDD.n90 164.505
R59 VDD.n95 VDD.n94 164.505
R60 VDD.n96 VDD.n95 164.505
R61 VDD.n100 VDD.n99 164.505
R62 VDD.n104 VDD.n58 164.505
R63 VDD.n105 VDD.n104 164.505
R64 VDD.t26 VDD.n55 164.505
R65 VDD.n109 VDD.t26 164.505
R66 VDD.n110 VDD.n52 164.505
R67 VDD.t0 VDD.n52 164.505
R68 VDD.n113 VDD.t0 164.505
R69 VDD.n114 VDD.n49 164.505
R70 VDD.t18 VDD.n49 164.505
R71 VDD.n117 VDD.t18 164.505
R72 VDD.n121 VDD.n46 164.505
R73 VDD.n123 VDD.n122 164.505
R74 VDD.n126 VDD.n43 164.505
R75 VDD.n128 VDD.n42 164.505
R76 VDD.n132 VDD.n131 164.505
R77 VDD.t20 VDD.n79 141.005
R78 VDD.t46 VDD.n84 141.005
R79 VDD.n101 VDD.t24 141.005
R80 VDD.n106 VDD.t28 141.005
R81 VDD.n118 VDD.t39 141.005
R82 VDD.n123 VDD.t16 141.005
R83 VDD.n131 VDD.t12 141.005
R84 VDD.t38 VDD.n69 117.504
R85 VDD.n69 VDD.t6 117.504
R86 VDD.t36 VDD.n66 117.504
R87 VDD.n66 VDD.t4 117.504
R88 VDD.t30 VDD.n64 117.504
R89 VDD.n64 VDD.t32 117.504
R90 VDD.n122 VDD.t9 117.504
R91 VDD.n127 VDD.t7 117.504
R92 VDD.t10 VDD.n127 117.504
R93 VDD.t40 VDD.n36 94.0029
R94 VDD.n79 VDD.t22 94.0029
R95 VDD.n84 VDD.t44 94.0029
R96 VDD.n101 VDD.t25 94.0029
R97 VDD.n106 VDD.t34 94.0029
R98 VDD.n110 VDD.t27 94.0029
R99 VDD.n114 VDD.t2 94.0029
R100 VDD.n118 VDD.t14 94.0029
R101 VDD.n76 VDD.t40 70.5023
R102 VDD.n75 VDD.t22 70.5023
R103 VDD.n72 VDD.t44 70.5023
R104 VDD.t25 VDD.n58 70.5023
R105 VDD.t34 VDD.n55 70.5023
R106 VDD.t27 VDD.n109 70.5023
R107 VDD.t2 VDD.n113 70.5023
R108 VDD.t14 VDD.n117 70.5023
R109 VDD.n86 VDD.t38 47.0017
R110 VDD.n89 VDD.t6 47.0017
R111 VDD.n91 VDD.t36 47.0017
R112 VDD.n94 VDD.t4 47.0017
R113 VDD.n96 VDD.t30 47.0017
R114 VDD.n99 VDD.t32 47.0017
R115 VDD.t9 VDD.n121 47.0017
R116 VDD.t7 VDD.n126 47.0017
R117 VDD.n128 VDD.t10 47.0017
R118 VDD.n80 VDD.t20 23.5011
R119 VDD.n85 VDD.t46 23.5011
R120 VDD.t24 VDD.n100 23.5011
R121 VDD.t28 VDD.n105 23.5011
R122 VDD.t39 VDD.n46 23.5011
R123 VDD.t16 VDD.n43 23.5011
R124 VDD.n42 VDD.t12 23.5011
R125 VDD.n6 VDD.n133 13.1265
R126 VDD.n37 VDD.n7 11.7458
R127 VDD.n141 VDD.n34 23.3338
R128 VDD.n74 VDD.n34 23.3338
R129 VDD.n77 VDD.n74 23.3338
R130 VDD.n77 VDD.n29 6.5635
R131 VDD.n78 VDD.n33 23.3338
R132 VDD.n78 VDD.n71 23.3338
R133 VDD.n82 VDD.n32 6.5635
R134 VDD.n82 VDD.n9 23.3338
R135 VDD.n83 VDD.n9 23.3338
R136 VDD.n26 VDD.n68 6.5635
R137 VDD.n87 VDD.n68 23.3338
R138 VDD.n87 VDD.n67 23.3338
R139 VDD.n88 VDD.n10 6.5635
R140 VDD.n88 VDD.n65 23.3338
R141 VDD.n92 VDD.n31 6.5635
R142 VDD.n92 VDD.n11 23.3338
R143 VDD.n93 VDD.n11 23.3338
R144 VDD.n30 VDD.n63 6.5635
R145 VDD.n97 VDD.n63 23.3338
R146 VDD.n97 VDD.n61 23.3338
R147 VDD.n98 VDD.n12 6.5635
R148 VDD.n98 VDD.n60 23.3338
R149 VDD.n102 VDD.n13 6.5635
R150 VDD.n102 VDD.n59 23.3338
R151 VDD.n103 VDD.n14 6.5635
R152 VDD.n103 VDD.n57 23.3338
R153 VDD.n107 VDD.n25 6.5635
R154 VDD.n107 VDD.n15 23.3338
R155 VDD.n108 VDD.n15 23.3338
R156 VDD.n16 VDD.n54 6.5635
R157 VDD.n111 VDD.n54 23.3338
R158 VDD.n18 VDD.n17 6.5635
R159 VDD.n112 VDD.n17 23.3338
R160 VDD.n28 VDD.n51 6.5635
R161 VDD.n115 VDD.n51 23.3338
R162 VDD.n20 VDD.n19 6.5635
R163 VDD.n116 VDD.n19 23.3338
R164 VDD.n27 VDD.n48 6.5635
R165 VDD.n119 VDD.n48 23.3338
R166 VDD.n119 VDD.n47 23.3338
R167 VDD.n120 VDD.n21 6.5635
R168 VDD.n120 VDD.n45 23.3338
R169 VDD.n124 VDD.n45 23.3338
R170 VDD.n124 VDD.n24 6.5635
R171 VDD.n125 VDD.n44 23.3338
R172 VDD.n22 VDD.n41 6.5635
R173 VDD.n129 VDD.n41 23.3338
R174 VDD.n129 VDD.n39 23.3338
R175 VDD.n23 VDD.n39 6.5635
R176 VDD.n130 VDD.n8 23.3338
R177 VDD.n136 VDD.n2 11.7552
R178 VDD.n3 VDD.n50 15.2628
R179 VDD.n3 VDD.n53 15.2628
R180 VDD.n0 VDD.n56 15.2628
R181 VDD.n5 VDD.n70 15.2628
R182 VDD.n0 VDD.n62 15.2628
R183 VDD.n134 VDD.n4 15.2537
R184 VDD.n141 VDD.n35 15.2088
R185 VDD.n141 VDD.n140 15.0005
R186 VDD VDD.n141 15.0005
R187 VDD.n36 VDD.n34 15.0005
R188 VDD VDD.n34 15.0005
R189 VDD.n76 VDD.n74 15.0005
R190 VDD.n74 VDD 15.0005
R191 VDD.n77 VDD.t42 15.0005
R192 VDD VDD.n29 4.21975
R193 VDD.n75 VDD.n33 15.0005
R194 VDD.n29 VDD.n33 6.5635
R195 VDD.n79 VDD.n78 15.0005
R196 VDD.n78 VDD.n5 15.0005
R197 VDD.n80 VDD.n71 15.0005
R198 VDD.n32 VDD.n71 6.5635
R199 VDD.n82 VDD.n81 15.0005
R200 VDD.n5 VDD.n32 4.21975
R201 VDD.n72 VDD.n9 15.0005
R202 VDD.n5 VDD.n9 15.0005
R203 VDD.n84 VDD.n83 15.0005
R204 VDD.n83 VDD.n26 6.5635
R205 VDD.n85 VDD.n68 15.0005
R206 VDD.n26 VDD.n5 4.21975
R207 VDD.n87 VDD.n86 15.0005
R208 VDD.n5 VDD.n87 15.0005
R209 VDD.n69 VDD.n67 15.0005
R210 VDD.n10 VDD.n67 6.5635
R211 VDD.n89 VDD.n88 15.0005
R212 VDD.n10 VDD.n0 4.21975
R213 VDD.n90 VDD.n65 15.0005
R214 VDD.n31 VDD.n65 6.5635
R215 VDD.n92 VDD.n91 15.0005
R216 VDD.n0 VDD.n31 4.21975
R217 VDD.n66 VDD.n11 15.0005
R218 VDD.n0 VDD.n11 15.0005
R219 VDD.n94 VDD.n93 15.0005
R220 VDD.n93 VDD.n30 6.5635
R221 VDD.n95 VDD.n63 15.0005
R222 VDD.n30 VDD.n0 4.21975
R223 VDD.n97 VDD.n96 15.0005
R224 VDD.n0 VDD.n97 15.0005
R225 VDD.n64 VDD.n61 15.0005
R226 VDD.n12 VDD.n61 6.5635
R227 VDD.n99 VDD.n98 15.0005
R228 VDD.n12 VDD.n0 4.21975
R229 VDD.n100 VDD.n60 15.0005
R230 VDD.n60 VDD.n13 6.5635
R231 VDD.n102 VDD.n101 15.0005
R232 VDD.n0 VDD.n13 4.21975
R233 VDD.n59 VDD.n58 15.0005
R234 VDD.n14 VDD.n59 6.5635
R235 VDD.n104 VDD.n103 15.0005
R236 VDD.n14 VDD.n0 4.21975
R237 VDD.n105 VDD.n57 15.0005
R238 VDD.n25 VDD.n57 6.5635
R239 VDD.n107 VDD.n106 15.0005
R240 VDD.n0 VDD.n25 4.21975
R241 VDD.n15 VDD.n55 15.0005
R242 VDD.n0 VDD.n15 15.0005
R243 VDD.t26 VDD.n108 15.0005
R244 VDD.n108 VDD.n16 6.5635
R245 VDD.n109 VDD.n54 15.0005
R246 VDD.n16 VDD.n0 4.21975
R247 VDD.n111 VDD.n110 15.0005
R248 VDD.n18 VDD.n111 6.5635
R249 VDD.n17 VDD.n52 15.0005
R250 VDD.n0 VDD.n18 4.21975
R251 VDD.t0 VDD.n112 15.0005
R252 VDD.n112 VDD.n28 6.5635
R253 VDD.n113 VDD.n51 15.0005
R254 VDD.n28 VDD.n3 4.21975
R255 VDD.n115 VDD.n114 15.0005
R256 VDD.n20 VDD.n115 6.5635
R257 VDD.n19 VDD.n49 15.0005
R258 VDD.n3 VDD.n20 4.21975
R259 VDD.t18 VDD.n116 15.0005
R260 VDD.n116 VDD.n27 6.5635
R261 VDD.n117 VDD.n48 15.0005
R262 VDD.n27 VDD.n3 4.21975
R263 VDD.n119 VDD.n118 15.0005
R264 VDD.n3 VDD.n119 15.0005
R265 VDD.n47 VDD.n46 15.0005
R266 VDD.n21 VDD.n47 6.5635
R267 VDD.n121 VDD.n120 15.0005
R268 VDD.n21 VDD.n3 4.21975
R269 VDD.n122 VDD.n45 15.0005
R270 VDD.n45 VDD.n3 15.0005
R271 VDD.n124 VDD.n123 15.0005
R272 VDD.n3 VDD.n24 4.21975
R273 VDD.n44 VDD.n43 15.0005
R274 VDD.n24 VDD.n44 6.5635
R275 VDD.n126 VDD.n125 15.0005
R276 VDD.n125 VDD.n22 6.5635
R277 VDD.n127 VDD.n41 15.0005
R278 VDD.n22 VDD.n4 4.21975
R279 VDD.n129 VDD.n128 15.0005
R280 VDD.n4 VDD.n129 15.0005
R281 VDD.n42 VDD.n39 15.0005
R282 VDD.n4 VDD.n23 4.21975
R283 VDD.n131 VDD.n130 15.0005
R284 VDD.n130 VDD.n23 6.5635
R285 VDD.n4 VDD.n8 15.0005
R286 VDD.n35 VDD 15.0005
R287 VDD.n1 VDD.n2 5.36889
R288 VDD VDD.n2 4.81705
R289 VDD.n140 VDD.n135 15.0005
R290 VDD.n6 VDD.n4 4.21975
R291 VDD.n6 VDD.n38 13.1265
R292 VDD.n4 VDD.n7 4.21975
R293 VDD.n138 VDD.n136 12.9188
R294 VDD.n0 VDD.t5 10.8973
R295 VDD.n0 VDD.t37 10.8973
R296 VDD.n3 VDD.t17 10.895
R297 VDD.n4 VDD.t13 10.8927
R298 VDD.n5 VDD.t21 10.8927
R299 VDD VDD.n73 7.85998
R300 VDD.n137 VDD 7.85998
R301 VDD.n4 VDD.n40 7.85998
R302 VDD.n138 VDD.n135 6.64275
R303 VDD.n134 VDD.n133 6.5635
R304 VDD.n7 VDD.n38 13.1265
R305 VDD.n139 VDD.n35 5.52732
R306 VDD.n139 VDD.n1 5.52732
R307 VDD.n8 VDD.n37 5.18282
R308 VDD.n132 VDD.n37 4.91009
R309 VDD.n140 VDD.n139 4.73784
R310 VDD VDD.n138 4.52391
R311 VDD.n140 VDD.n136 4.30808
R312 VDD.n133 VDD.n132 4.21975
R313 VDD.n132 VDD.n38 4.21975
R314 VDD.n50 VDD.t19 3.03552
R315 VDD.n50 VDD.t15 3.03552
R316 VDD.n53 VDD.t1 3.03552
R317 VDD.n53 VDD.t3 3.03552
R318 VDD.n56 VDD.t29 3.03552
R319 VDD.n56 VDD.t35 3.03552
R320 VDD.n70 VDD.t45 3.03552
R321 VDD.n70 VDD.t47 3.03552
R322 VDD.n73 VDD.t43 3.03552
R323 VDD.n73 VDD.t23 3.03552
R324 VDD.n137 VDD.t41 3.03552
R325 VDD.n40 VDD.t8 3.03552
R326 VDD.n40 VDD.t11 3.03552
R327 VDD.n62 VDD.t31 3.03552
R328 VDD.n62 VDD.t33 3.03552
R329 VDD.n1 VDD.n137 2.88292
R330 VDD.n3 VDD.n0 2.13597
R331 VDD.n4 VDD.n3 1.55718
R332 VDD.n0 VDD.n5 1.35943
R333 VDD.n5 VDD 1.30397
R334 VSS.n153 VSS.n152 1923.3
R335 VSS.n156 VSS.n155 513.399
R336 VSS.n89 VSS.n88 513.399
R337 VSS.n89 VSS.n87 513.399
R338 VSS.n93 VSS.n92 513.399
R339 VSS.n93 VSS.n84 513.399
R340 VSS.n96 VSS.n84 513.399
R341 VSS.n97 VSS.n82 513.399
R342 VSS.n99 VSS.n82 513.399
R343 VSS.n101 VSS.n100 513.399
R344 VSS.n101 VSS.n79 513.399
R345 VSS.n104 VSS.n79 513.399
R346 VSS.n106 VSS.n105 513.399
R347 VSS.n106 VSS.n78 513.399
R348 VSS.n110 VSS.n109 513.399
R349 VSS.n111 VSS.n110 513.399
R350 VSS.n111 VSS.n75 513.399
R351 VSS.n115 VSS.n114 513.399
R352 VSS.n116 VSS.n115 513.399
R353 VSS.n120 VSS.n71 513.399
R354 VSS.n121 VSS.n120 513.399
R355 VSS.n122 VSS.n121 513.399
R356 VSS.n125 VSS.n68 513.399
R357 VSS.n126 VSS.n125 513.399
R358 VSS.n127 VSS.n66 513.399
R359 VSS.n130 VSS.n66 513.399
R360 VSS.n131 VSS.n130 513.399
R361 VSS.n132 VSS.n64 513.399
R362 VSS.n135 VSS.n64 513.399
R363 VSS.n136 VSS.n135 513.399
R364 VSS.n137 VSS.n60 513.399
R365 VSS.n140 VSS.n60 513.399
R366 VSS.n142 VSS.n141 513.399
R367 VSS.n142 VSS.n59 513.399
R368 VSS.n146 VSS.n145 513.399
R369 VSS.n147 VSS.n146 513.399
R370 VSS.n147 VSS.n56 513.399
R371 VSS.n137 VSS.t13 495.063
R372 VSS.n78 VSS.t14 490.481
R373 VSS.n105 VSS.t2 458.392
R374 VSS.n116 VSS.t16 417.137
R375 VSS.t12 VSS.n99 412.553
R376 VSS.n87 VSS.t10 380.466
R377 VSS.t18 VSS.n68 366.714
R378 VSS.n97 VSS.t22 343.795
R379 VSS.n141 VSS.t8 343.795
R380 VSS.t4 VSS.n126 339.211
R381 VSS.n59 VSS.t6 325.459
R382 VSS.n114 VSS.t21 293.372
R383 VSS.n88 VSS.t19 288.788
R384 VSS.t0 VSS.n131 288.788
R385 VSS.n156 VSS.t19 224.613
R386 VSS.n132 VSS.t0 224.613
R387 VSS.n75 VSS.t21 220.029
R388 VSS.n145 VSS.t6 187.941
R389 VSS.n127 VSS.t4 174.19
R390 VSS.t22 VSS.n96 169.606
R391 VSS.t8 VSS.n140 169.606
R392 VSS.n122 VSS.t18 146.685
R393 VSS.n92 VSS.t10 132.935
R394 VSS.n100 VSS.t12 100.847
R395 VSS.t16 VSS.n71 96.2628
R396 VSS.t2 VSS.n104 55.0075
R397 VSS.n148 VSS.n39 6.5635
R398 VSS.n134 VSS.n63 23.3338
R399 VSS.n138 VSS.n38 6.5635
R400 VSS.n138 VSS.n62 23.3338
R401 VSS.n129 VSS.n53 23.3338
R402 VSS.n123 VSS.n70 23.3338
R403 VSS.n123 VSS.n69 23.3338
R404 VSS.n124 VSS.n37 6.5635
R405 VSS.n124 VSS.n51 23.3338
R406 VSS.n112 VSS.n74 23.3338
R407 VSS.n113 VSS.n35 6.5635
R408 VSS.n113 VSS.n73 23.3338
R409 VSS.n117 VSS.n36 6.5635
R410 VSS.n107 VSS.n77 23.3338
R411 VSS.n32 VSS.n81 6.5635
R412 VSS.n102 VSS.n81 23.3338
R413 VSS.n34 VSS.n33 6.5635
R414 VSS.n157 VSS.n55 23.3338
R415 VSS.n143 VSS.n52 23.251
R416 VSS.n98 VSS.n2 23.251
R417 VSS.n139 VSS.n41 6.53281
R418 VSS.n95 VSS.n46 23.1406
R419 VSS.n109 VSS.t14 22.9201
R420 VSS.n90 VSS.n43 6.49747
R421 VSS.n29 VSS.n9 6.43489
R422 VSS.n103 VSS.n33 22.4503
R423 VSS.n148 VSS.n54 22.3122
R424 VSS.n30 VSS.n11 6.38508
R425 VSS.n48 VSS.n77 6.34389
R426 VSS.n47 VSS.n46 6.34389
R427 VSS.n49 VSS.n70 6.30695
R428 VSS.n118 VSS.n117 21.5392
R429 VSS.n112 VSS.n31 6.23211
R430 VSS.n91 VSS.n50 21.3183
R431 VSS.n128 VSS.n40 6.18944
R432 VSS.n144 VSS.n44 6.17512
R433 VSS.n42 VSS.n17 6.15116
R434 VSS.n133 VSS.n45 6.13672
R435 VSS.n157 VSS.n22 20.3795
R436 VSS.n3 VSS.n2 7.67488
R437 VSS.n139 VSS.n5 19.88
R438 VSS.n95 VSS.n4 19.88
R439 VSS.n90 VSS.n24 18.4342
R440 VSS.t13 VSS.n136 18.3362
R441 VSS.n10 VSS.n9 15.9041
R442 VSS.n28 VSS.n55 15.8338
R443 VSS.n149 VSS.n57 15.8338
R444 VSS.n103 VSS.n19 6.08692
R445 VSS VSS.n153 15.2537
R446 VSS.n152 VSS.n0 15.2537
R447 VSS.n157 VSS.n156 15.0005
R448 VSS VSS.n157 15.0005
R449 VSS.n155 VSS.n55 15.0005
R450 VSS.n55 VSS 15.0005
R451 VSS.n90 VSS.n89 15.0005
R452 VSS VSS.n43 4.25277
R453 VSS.n88 VSS.n22 15.0005
R454 VSS.n23 VSS 4.54513
R455 VSS.n87 VSS.n50 15.0005
R456 VSS.n43 VSS.n50 6.49747
R457 VSS.n94 VSS.n93 15.0005
R458 VSS.n47 VSS.n94 6.34389
R459 VSS.n92 VSS.n91 15.0005
R460 VSS.n20 VSS 3.69536
R461 VSS.n46 VSS.n84 15.0005
R462 VSS VSS.n47 4.32955
R463 VSS.n4 VSS.n97 15.0005
R464 VSS.n96 VSS.n95 15.0005
R465 VSS.n95 VSS 15.0005
R466 VSS.n33 VSS.n79 15.0005
R467 VSS VSS.n34 4.21975
R468 VSS.n102 VSS.n101 15.0005
R469 VSS.n34 VSS.n102 6.5635
R470 VSS.n100 VSS.n81 15.0005
R471 VSS.n32 VSS 4.21975
R472 VSS.n99 VSS.n98 15.0005
R473 VSS.n98 VSS.n32 6.5635
R474 VSS.n2 VSS.n82 15.0005
R475 VSS VSS.n3 1.78457
R476 VSS.n105 VSS.n17 15.0005
R477 VSS VSS.n42 4.42592
R478 VSS.n104 VSS.n103 15.0005
R479 VSS.n19 VSS 2.97236
R480 VSS.n78 VSS.n77 15.0005
R481 VSS.n1 VSS.n48 4.32955
R482 VSS.n107 VSS.n106 15.0005
R483 VSS.n42 VSS.n107 6.15116
R484 VSS.n110 VSS.n15 15.0005
R485 VSS.n31 VSS.n15 6.23211
R486 VSS.n109 VSS.n108 15.0005
R487 VSS.n108 VSS.n48 6.34389
R488 VSS.n117 VSS.n116 15.0005
R489 VSS.n36 VSS.n1 4.21975
R490 VSS.n115 VSS.n73 15.0005
R491 VSS.n36 VSS.n73 6.5635
R492 VSS.n114 VSS.n113 15.0005
R493 VSS.n35 VSS.n1 4.21975
R494 VSS.n75 VSS.n74 15.0005
R495 VSS.n35 VSS.n74 6.5635
R496 VSS.n112 VSS.n111 15.0005
R497 VSS.n1 VSS.n31 4.38545
R498 VSS.n120 VSS.n119 15.0005
R499 VSS.n119 VSS.n49 6.30695
R500 VSS.n118 VSS.n71 15.0005
R501 VSS.n1 VSS.n14 3.52791
R502 VSS.n126 VSS.n51 15.0005
R503 VSS.n40 VSS.n51 6.18944
R504 VSS.n125 VSS.n124 15.0005
R505 VSS.n37 VSS.n1 4.21975
R506 VSS.n69 VSS.n68 15.0005
R507 VSS.n37 VSS.n69 6.5635
R508 VSS.n123 VSS.n122 15.0005
R509 VSS.n1 VSS.n123 15.0005
R510 VSS.n121 VSS.n70 15.0005
R511 VSS.n49 VSS.n1 4.34803
R512 VSS.n11 VSS.n66 15.0005
R513 VSS.n1 VSS.n30 4.30896
R514 VSS.n128 VSS.n127 15.0005
R515 VSS.n40 VSS.n1 4.40678
R516 VSS.n131 VSS.n53 15.0005
R517 VSS.n45 VSS.n53 6.13672
R518 VSS.n130 VSS.n129 15.0005
R519 VSS.n129 VSS.n30 6.38508
R520 VSS.n9 VSS.n64 15.0005
R521 VSS.n1 VSS.n29 4.28405
R522 VSS.n133 VSS.n132 15.0005
R523 VSS.n45 VSS.n1 4.43314
R524 VSS.n62 VSS.n60 15.0005
R525 VSS.n41 VSS.n62 6.53281
R526 VSS.n138 VSS.n137 15.0005
R527 VSS.n0 VSS.n38 4.21975
R528 VSS.n136 VSS.n63 15.0005
R529 VSS.n63 VSS.n38 6.5635
R530 VSS.n135 VSS.n134 15.0005
R531 VSS.n134 VSS.n29 6.43489
R532 VSS.n141 VSS.n5 15.0005
R533 VSS.n0 VSS.n6 1.78457
R534 VSS.n140 VSS.n139 15.0005
R535 VSS.n41 VSS.n0 4.23509
R536 VSS.n59 VSS.n52 15.0005
R537 VSS.n44 VSS.n52 6.17512
R538 VSS.n143 VSS.n142 15.0005
R539 VSS.n146 VSS.n54 15.0005
R540 VSS.n0 VSS.n8 3.04501
R541 VSS.n145 VSS.n144 15.0005
R542 VSS.n44 VSS.n0 4.41394
R543 VSS.n57 VSS.n56 15.0005
R544 VSS.n39 VSS.n57 6.5635
R545 VSS.n148 VSS.n147 15.0005
R546 VSS.n0 VSS.n39 4.21975
R547 VSS.n27 VSS.n0 4.21975
R548 VSS.n150 VSS.n27 13.1265
R549 VSS.n149 VSS.n0 15.0005
R550 VSS VSS.n28 15.0005
R551 VSS VSS.n26 4.21975
R552 VSS.n8 VSS.n54 5.86897
R553 VSS.n12 VSS.n11 13.9162
R554 VSS.n108 VSS.n16 12.2897
R555 VSS.n94 VSS.n21 12.2897
R556 VSS.n119 VSS.n13 10.8439
R557 VSS.n7 VSS.t7 10.5005
R558 VSS.n5 VSS.t9 10.5005
R559 VSS.n10 VSS.t1 10.5005
R560 VSS.n12 VSS.t5 10.5005
R561 VSS.n13 VSS.t17 10.5005
R562 VSS.n16 VSS.t15 10.5005
R563 VSS.n18 VSS.t3 10.5005
R564 VSS.n4 VSS.t23 10.5005
R565 VSS.n21 VSS.t11 10.5005
R566 VSS.n24 VSS.t20 10.5005
R567 VSS.n118 VSS.n14 4.42026
R568 VSS.n16 VSS.n15 7.95231
R569 VSS.n91 VSS.n20 3.91791
R570 VSS.n24 VSS.n23 0.684809
R571 VSS.n21 VSS.n20 1.95946
R572 VSS.n4 VSS.n3 2.73081
R573 VSS.n19 VSS.n18 3.04396
R574 VSS.n1 VSS.n16 7.5005
R575 VSS.n14 VSS.n13 2.21063
R576 VSS.n1 VSS.n12 7.5005
R577 VSS.n1 VSS.n10 7.5005
R578 VSS.n6 VSS.n5 2.73081
R579 VSS.n8 VSS.n7 2.93499
R580 VSS.n7 VSS.n58 6.6005
R581 VSS.n5 VSS.n61 6.6005
R582 VSS.n10 VSS.n65 6.6005
R583 VSS.n12 VSS.n67 6.6005
R584 VSS.n18 VSS.n80 6.6005
R585 VSS.n4 VSS.n83 6.6005
R586 VSS.n24 VSS.n86 6.6005
R587 VSS.n153 VSS.n25 6.5635
R588 VSS.n152 VSS.n151 6.5635
R589 VSS.n154 VSS.n28 6.5635
R590 VSS.n154 VSS.n26 13.1265
R591 VSS.n26 VSS.n25 13.1265
R592 VSS.n150 VSS.n149 6.5635
R593 VSS.n151 VSS.n27 13.1265
R594 VSS.n21 VSS.n85 7.0505
R595 VSS.n16 VSS.n76 7.0505
R596 VSS.n13 VSS.n72 7.0505
R597 VSS.n143 VSS.n6 7.67488
R598 VSS.n12 VSS.n128 6.7758
R599 VSS.n144 VSS.n7 6.23363
R600 VSS.n18 VSS.n17 5.33002
R601 VSS.n10 VSS.n133 4.78785
R602 VSS.n0 VSS 4.68397
R603 VSS.n0 VSS 4.3633
R604 VSS.n151 VSS.n56 4.21975
R605 VSS.n150 VSS.n56 4.21975
R606 VSS.n155 VSS.n154 4.21975
R607 VSS.n155 VSS.n25 4.21975
R608 VSS.n1 VSS 3.70637
R609 VSS.n1 VSS 3.32763
R610 VSS.n0 VSS 3.04529
R611 VSS.n0 VSS 2.82789
R612 VSS.n1 VSS 2.6629
R613 VSS.n1 VSS 2.38251
R614 VSS.n23 VSS.n22 1.36862
R615 VSS.n1 VSS 2.12574
R616 VSS.n1 VSS.n0 2.03004
R617 VSS.n1 VSS 1.9973
R618 VSS.n1 VSS 1.84978
R619 VSS.n1 VSS 1.67508
R620 VSS.n1 VSS 1.22382
R621 a_4028_987.n1 a_4028_987.t2 11.571
R622 a_4028_987.t0 a_4028_987.n1 11.5552
R623 a_4028_987.n1 a_4028_987.n0 7.5005
R624 a_4028_987.n0 a_4028_987.t3 3.03552
R625 a_4028_987.n0 a_4028_987.t1 3.03552
R626 a_2812_987.t2 a_2812_987.n1 11.571
R627 a_2812_987.n1 a_2812_987.t0 11.5552
R628 a_2812_987.n1 a_2812_987.n0 7.5005
R629 a_2812_987.n0 a_2812_987.t1 3.03552
R630 a_2812_987.n0 a_2812_987.t3 3.03552
R631 a_2044_987.t2 a_2044_987.n1 11.571
R632 a_2044_987.n1 a_2044_987.t0 11.5552
R633 a_2044_987.n1 a_2044_987.n0 7.5005
R634 a_2044_987.n0 a_2044_987.t1 3.03552
R635 a_2044_987.n0 a_2044_987.t3 3.03552
R636 a_828_987.t2 a_828_987.n1 11.571
R637 a_828_987.n1 a_828_987.t0 11.5552
R638 a_828_987.n1 a_828_987.n0 7.5005
R639 a_828_987.n0 a_828_987.t1 3.03552
R640 a_828_987.n0 a_828_987.t3 3.03552
R641 out2.n9 out2.n6 307.5
R642 out2.n3 out2.t5 87.0243
R643 out2.n12 out2.n11 80.1922
R644 out2.n17 out2.t7 79.2267
R645 out2.n3 out2.t6 77.0243
R646 out2.n11 out2.n10 70.2658
R647 out2.n17 out2.t8 39.6434
R648 out2.n0 out2.n15 5.19173
R649 out2 out2.n2 31.5568
R650 out2 out2.t4 28.1215
R651 out2.n1 out2.n0 6.54491
R652 out2.n7 out2.n6 20.7085
R653 out2.n2 out2.n17 17.6355
R654 out2.n5 out2.n4 17.0593
R655 out2 out2.n16 15.3863
R656 out2.n7 out2.n5 12.0226
R657 out2.n2 out2.t0 11.3133
R658 out2.n10 out2.n6 8.78735
R659 out2.n13 out2.n3 8.48624
R660 out2.n13 out2.n12 7.68589
R661 out2.n0 out2.n14 1.1634
R662 out2.n8 out2.n4 5.61157
R663 out2.t3 out2.n9 4.98488
R664 out2.n11 out2.n5 4.59482
R665 out2.t2 out2.n14 4.13843
R666 out2.n16 out2.n14 4.13843
R667 out2.n8 out2.n7 3.26079
R668 out2.n9 out2.n8 2.65923
R669 out2.n12 out2.n4 2.44948
R670 out2.n10 out2.t3 2.28378
R671 out2.n16 out2.n1 4.29563
R672 out2.n2 out2.t1 10.7066
R673 out2 out2.n13 2.26961
R674 out2.n1 out2.t2 2.26409
R675 in2.t4 in2.n24 229.018
R676 in2.n12 in2.n8 210
R677 in2.n26 in2.n25 210
R678 in2.n15 in2.n5 202.5
R679 in2.t4 in2.n3 4.02627
R680 in2.n8 in2.n5 112.501
R681 in2.n16 in2.n15 112.501
R682 in2.n25 in2.n22 112.501
R683 in2.n19 in2.t7 77.8576
R684 in2.n19 in2.t8 39.6434
R685 in2.n2 in2.n28 10.8079
R686 in2.n9 in2.n7 35.0626
R687 in2.n12 in2.n11 31.9491
R688 in2.n28 in2.n26 31.9491
R689 in2.n0 in2.n21 31.5259
R690 in2.n18 in2.n4 31.1985
R691 in2.n18 in2.n17 30.5821
R692 in2.n13 in2.n12 22.7684
R693 in2.n26 in2.n24 22.7684
R694 in2.n16 in2.n14 22.5005
R695 in2.n14 in2.n7 17.1346
R696 in2 in2.n18 15.7254
R697 in2.n17 in2.t1 15.2591
R698 in2.n29 in2.t4 15.2591
R699 in2.n21 in2.n19 15.1764
R700 in2.n21 in2.n20 15.0005
R701 in2.n0 in2.n29 15.0005
R702 in2.n14 in2.n13 11.777
R703 in2.n9 in2.n1 10.8735
R704 in2.n13 in2.n6 7.5005
R705 in2.n15 in2.n6 7.5005
R706 in2.t1 in2.n16 7.5005
R707 in2.n24 in2.n23 7.5005
R708 in2.n22 in2.n3 209.323
R709 in2.t1 in2.n1 0.489634
R710 in2.t4 in2.n2 0.379787
R711 in2.n0 in2.t6 12.9092
R712 in2.t1 in2.n7 4.82859
R713 in2.n3 in2.n23 0.252579
R714 in2.n8 in2.n6 4.16717
R715 in2.n25 in2.n23 4.16717
R716 in2.n17 in2.n5 3.87981
R717 in2.n29 in2.n22 3.87981
R718 in2.n1 in2.n5 9.25828
R719 in2.n2 in2.n22 9.36437
R720 in2.t1 in2.n6 4.42579
R721 in2.n20 in2.t2 3.03552
R722 in2.n20 in2.t3 3.03552
R723 in2.n4 in2.t5 3.03552
R724 in2.n4 in2.t0 3.03552
R725 in2.n11 in2.n10 2.72827
R726 in2.n28 in2.n27 2.72827
R727 in2.n11 in2.n9 2.38736
R728 in2 in2.n0 1.95503
R729 in1.t1 in1.n23 229.018
R730 in1.t5 in1.n2 4.01391
R731 in1.t5 in1.n0 0.361235
R732 in1.n25 in1.n24 210
R733 in1.n8 in1.n7 202.5
R734 in1.t1 in1.n5 4.02627
R735 in1.n11 in1.n8 112.501
R736 in1.n24 in1.n21 112.501
R737 in1.n34 in1.n32 112.501
R738 in1.n36 in1.n32 97.5005
R739 in1.n18 in1.t7 82.5005
R740 in1.n33 in1.t6 58.9602
R741 in1.n20 in1.n18 55.6093
R742 in1.n14 in1.n13 47.6267
R743 in1.n18 in1.t8 39.6434
R744 in1.n4 in1.n27 10.8079
R745 in1.n12 in1.n3 34.7947
R746 in1.n27 in1.n25 31.9491
R747 in1.n17 in1.n6 31.1578
R748 in1.n17 in1.n16 30.4718
R749 in1.n1 in1.n20 24.1085
R750 in1.n25 in1.n23 22.7684
R751 in1.n11 in1.n9 22.5005
R752 in1.n33 in1.n31 20.455
R753 in1.n32 in1.n30 17.2505
R754 in1.n3 in1.n9 17.1346
R755 in1 in1.n17 15.9469
R756 in1.n28 in1.t1 15.2591
R757 in1.n1 in1.n28 15.0005
R758 in1.n20 in1.n19 15.0005
R759 in1.n38 in1.n30 14.0005
R760 in1.n14 in1.n9 11.777
R761 in1.n34 in1.n33 11.5184
R762 in1.n38 in1.n37 11.4158
R763 in1.t6 in1.n29 9.38071
R764 in1.n37 in1.n31 9.063
R765 in1.n30 in1.n29 8.03621
R766 in1.n12 in1.n0 11.6304
R767 in1.n15 in1.n14 7.5005
R768 in1.n15 in1.n8 7.5005
R769 in1.t5 in1.n11 7.5005
R770 in1.n23 in1.n22 7.5005
R771 in1.n21 in1.n5 209.323
R772 in1.n35 in1.n31 7.5005
R773 in1.n37 in1.n36 7.5005
R774 in1.n16 in1.t5 6.98326
R775 in1.t1 in1.n4 0.379787
R776 in1 in1.n39 5.0005
R777 in1.t5 in1.n3 4.82859
R778 in1.n39 in1.n29 4.6505
R779 in1.n5 in1.n22 0.252579
R780 in1.n0 in1.n7 9.20397
R781 in1.n15 in1.n2 0.0778758
R782 in1.n7 in1.n2 116.513
R783 in1.n24 in1.n22 4.16717
R784 in1.n35 in1.n34 4.01836
R785 in1.n13 in1.n12 3.95439
R786 in1.n16 in1.n7 3.87981
R787 in1.n28 in1.n21 3.87981
R788 in1.n4 in1.n21 9.36437
R789 in1.n36 in1.n35 3.7505
R790 in1.n6 in1.t2 3.03552
R791 in1.n6 in1.t3 3.03552
R792 in1.n19 in1.t4 3.03552
R793 in1.n19 in1.t0 3.03552
R794 in1.n27 in1.n26 2.72827
R795 in1.n39 in1.n38 2.1005
R796 in1 in1.n1 1.86584
R797 in1.n13 in1.n10 1.40041
R798 CLKb.n18 CLKb.t0 120.001
R799 CLKb.n3 CLKb.n17 115.718
R800 CLKb.n8 CLKb.t5 103.691
R801 CLKb.n7 CLKb.t7 82.5005
R802 CLKb.n20 CLKb.n19 67.4693
R803 CLKb.n8 CLKb.t6 65.3576
R804 CLKb.n10 CLKb.n1 47.2395
R805 CLKb.n7 CLKb.t8 39.6434
R806 CLKb.n19 CLKb.n18 34.8011
R807 CLKb CLKb.n2 30.5882
R808 CLKb.n14 CLKb.n7 21.3004
R809 CLKb.n18 CLKb.n17 20.0898
R810 CLKb.n13 CLKb.t4 28.4989
R811 CLKb CLKb.n16 15.5995
R812 CLKb.n11 CLKb.n1 54.3441
R813 CLKb.n2 CLKb.n3 5.1751
R814 CLKb.n1 CLKb.n0 7.73582
R815 CLKb.n12 CLKb.n8 12.9393
R816 CLKb.n6 CLKb.n3 2.89242
R817 CLKb.n12 CLKb.n11 9.29605
R818 CLKb.n16 CLKb.n15 8.19746
R819 CLKb.n10 CLKb.n9 7.72777
R820 CLKb.n6 CLKb.n5 1.97827
R821 CLKb.n19 CLKb.n4 7.5005
R822 CLKb.t3 CLKb.n10 7.5005
R823 CLKb.n20 CLKb.n17 4.52242
R824 CLKb.n5 CLKb.t0 1.09191
R825 CLKb.n5 CLKb.n4 1.96464
R826 CLKb.n0 CLKb.n9 9.25248
R827 CLKb.n14 CLKb.n13 3.67893
R828 CLKb.n11 CLKb.n9 3.28968
R829 CLKb.n15 CLKb.t1 3.03552
R830 CLKb.n15 CLKb.t2 3.03552
R831 CLKb.n2 CLKb.t0 14.0052
R832 CLKb.n2 CLKb.n4 4.18614
R833 CLKb.n6 CLKb.n20 1.72383
R834 CLKb.n0 CLKb.t3 1.34655
R835 CLKb.n16 CLKb.n14 1.22815
R836 CLKb.n13 CLKb.n12 1.17841
C0 out1 in1 0.93048f
C1 out1 CLKb 0.37598f
C2 in2 VDD 0.55331f
C3 out1 CLKN 0.81077f
C4 out2 CLKN 0.4812f
C5 out1 a_2903_203r# 0.10484f
C6 CLK VDD 0.52851f
C7 CLKb in2 0.66901f
C8 D a_945_203r# 0.10735f
C9 CLKN in2 0.58367f
C10 out2 QN 0.34967f
C11 Q QN 0.32353f
C12 a_2135_203r# out1 0.21267f
C13 D VDD 0.38514f
C14 a_4107_203r# out2 0.23766f
C15 out2 in2 0.95539f
C16 CLKN CLK 0.29463f
C17 CLKb VDD 1.38283f
C18 VDD in1 0.56016f
C19 CLKb D 0.24198f
C20 CLKN VDD 1.78185f
C21 CLKb in1 0.80783f
C22 CLKN D 0.27925f
C23 out1 VDD 0.93118f
C24 out2 VDD 1.19022f
C25 Q VDD 0.3168f
C26 CLKN CLKb 0.94378f
C27 CLKN in1 0.60301f
C28 QN VDD 0.73006f
C29 Q VSS 0.52713f
C30 QN VSS 1.09427f
C31 D VSS 0.92591f
C32 CLK VSS 0.97637f
C33 VDD VSS 15.16656f
C34 a_4107_203r# VSS 0.21883f
C35 a_2135_203r# VSS 0.32928f
C36 a_945_203r# VSS 0.2435f
C37 out2 VSS 1.68881f
C38 in2 VSS 0.83588f
C39 out1 VSS 0.15274f
C40 in1 VSS 0.95279f
C41 CLKb VSS 1.59527f
C42 CLKb.n1 VSS 0.25778f
C43 CLKb.n7 VSS 0.11816f
C44 CLKb.n8 VSS 0.24963f
C45 CLKb.n11 VSS 0.21439f
C46 CLKb.n12 VSS 0.618f
C47 CLKb.n13 VSS 0.46579f
C48 CLKb.n14 VSS 0.4166f
C49 CLKb.t2 VSS 0.89946f
C50 CLKb.n15 VSS 0.10158f
C51 CLKb.n16 VSS 0.33302f
C52 CLKb.n19 VSS 0.11713f
C53 in1.t5 VSS 0.3108f
C54 in1.n1 VSS 0.39139f
C55 in1.t1 VSS 0.11031f
C56 in1.n6 VSS 0.11857f
C57 in1.n17 VSS 0.4156f
C58 in1.n18 VSS 0.12483f
C59 in1.t0 VSS 0.1084f
C60 in1.n20 VSS 0.29168f
C61 in1.n33 VSS 0.13069f
C62 in2.n0 VSS 0.582f
C63 in2.t4 VSS 0.11425f
C64 in2.t0 VSS 0.11461f
C65 in2.n4 VSS 0.13802f
C66 in2.n18 VSS 0.41911f
C67 in2.n19 VSS 0.13276f
C68 in2.t2 VSS 0.10944f
C69 in2.n21 VSS 0.40418f
C70 out2.n2 VSS 0.52541f
C71 out2.n3 VSS 0.16003f
C72 out2.n10 VSS 0.12817f
C73 out2.n11 VSS 0.18874f
C74 out2.n13 VSS 0.2799f
C75 out2.t2 VSS 0.21725f
C76 out2.n15 VSS 0.13367f
C77 out2.t1 VSS 0.15999f
C78 out2.n17 VSS 0.11793f
C79 out2.t0 VSS 0.15143f
C80 a_828_987.t0 VSS 0.20972f
C81 a_828_987.t3 VSS 0.10008f
C82 a_828_987.n1 VSS 0.44402f
C83 a_828_987.t2 VSS 0.1891f
C84 a_2044_987.t0 VSS 0.14423f
C85 a_2044_987.n1 VSS 0.44825f
C86 a_2044_987.t2 VSS 0.14454f
C87 a_2812_987.t0 VSS 0.16541f
C88 a_2812_987.t1 VSS 0.11797f
C89 a_2812_987.t3 VSS 0.59303f
C90 a_2812_987.n1 VSS 0.45147f
C91 a_2812_987.t2 VSS 0.14558f
C92 a_4028_987.t2 VSS 0.19259f
C93 a_4028_987.t3 VSS 0.1091f
C94 a_4028_987.t1 VSS 0.10501f
C95 a_4028_987.n0 VSS 0.10271f
C96 a_4028_987.n1 VSS 0.47525f
C97 a_4028_987.t0 VSS 0.22727f
C98 VSS.t7 VSS 0.13919f
C99 VSS.t23 VSS 0.18525f
C100 VSS.t20 VSS 0.13836f
C101 VSS.t5 VSS 0.19786f
C102 VSS.t1 VSS 0.16602f
C103 VDD.n0 VSS 0.51072f
C104 VDD.n3 VSS 0.29885f
C105 VDD.n4 VSS 0.19979f
C106 VDD.n5 VSS 0.18284f
C107 VDD.n36 VSS 0.11058f
C108 VDD.n49 VSS 0.14074f
C109 VDD.n52 VSS 0.14074f
C110 VDD.n55 VSS 0.10053f
C111 VDD.t35 VSS 0.55452f
C112 VDD.n58 VSS 0.10053f
C113 VDD.n64 VSS 0.10053f
C114 VDD.n66 VSS 0.10053f
C115 VDD.n69 VSS 0.10053f
C116 VDD.t21 VSS 0.88115f
C117 VDD.n72 VSS 0.10053f
C118 VDD.n75 VSS 0.10053f
C119 VDD.n76 VSS 0.10053f
C120 VDD.t42 VSS 0.14074f
C121 VDD.n79 VSS 0.10053f
C122 VDD.n81 VSS 0.14074f
C123 VDD.n84 VSS 0.10053f
C124 VDD.n90 VSS 0.14074f
C125 VDD.n95 VSS 0.14074f
C126 VDD.n101 VSS 0.10053f
C127 VDD.n104 VSS 0.14074f
C128 VDD.n106 VSS 0.10053f
C129 VDD.t26 VSS 0.14074f
C130 VDD.n109 VSS 0.10053f
C131 VDD.n110 VSS 0.11058f
C132 VDD.t0 VSS 0.14074f
C133 VDD.n113 VSS 0.10053f
C134 VDD.n114 VSS 0.11058f
C135 VDD.t18 VSS 0.14074f
C136 VDD.n117 VSS 0.10053f
C137 VDD.n118 VSS 0.10053f
C138 VDD.n122 VSS 0.12063f
C139 VDD.n123 VSS 0.13069f
C140 VDD.n127 VSS 0.10053f
C141 VDD.n131 VSS 0.13069f
C142 VDD.n132 VSS 0.22367f
C143 VDD.n134 VSS 0.19879f
C144 VDD.n135 VSS 0.19879f
C145 VDD.n140 VSS 0.18346f
C146 D.n0 VSS 0.24815f
C147 QN.n6 VSS 0.11609f
C148 Q.t1 VSS 0.15003f
.ends
