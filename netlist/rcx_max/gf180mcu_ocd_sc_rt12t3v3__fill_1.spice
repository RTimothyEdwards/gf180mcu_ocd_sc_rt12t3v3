* NGSPICE file created from gf180mcu_ocd_sc_rt12t3v3__fill_1.ext - technology: gf180mcuD

.subckt gf180mcu_ocd_sc_rt12t3v3__fill_1 VDD VSS
R0 VDD.n9 VDD.n7 385.029
R1 VDD.n1 VDD.n5 13.8891
R2 VDD.n9 VDD.n6 377.529
R3 VDD.n5 VDD.n6 384.719
R4 VDD.n0 VDD.n7 15.2537
R5 VDD.n0 VDD.n2 5.751
R6 VDD.n2 VDD.n3 3.501
R7 VDD.n11 VDD.n0 15.0005
R8 VDD.n1 VDD.n4 5.751
R9 VDD.n11 VDD.n4 3.501
R10 VDD.n10 VDD.n2 3.501
R11 VDD.n4 VDD.n3 3.501
R12 VDD.n11 VDD.n5 0.17162
R13 VDD.n10 VDD.n9 7.5005
R14 VDD.n3 VDD.n6 7.5005
R15 VDD.n8 VDD.n1 6.06369
R16 VDD.n8 VDD.n7 3.5372
R17 VDD.n10 VDD.n8 3.4785
R18 VDD.n1 VDD.n0 1.59668
R19 VDD VDD.n0 0.0005
R20 VSS VSS.n0 0.0005
C0 VDD VSS 1.08765f
.ends
