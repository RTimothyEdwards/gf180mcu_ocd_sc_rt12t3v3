* NGSPICE file created from gf180mcu_ocd_sc_rt12t3v3__xor2_1.ext - technology: gf180mcuD

.subckt gf180mcu_ocd_sc_rt12t3v3__xor2_1 A B Y VDD VSS
X0 a_1317_987.t1 A.t2 VDD.t7 VDD.t6 pfet_03v3 ad=0.3341p pd=1.805u as=0.3341p ps=1.805u w=1.285u l=0.28u
X1 VDD.t5 A.t4 AN.t2 VDD.t4 pfet_03v3 ad=0.5654p pd=3.45u as=0.3341p ps=1.805u w=1.285u l=0.28u
X2 Y.t4 AN.t4 a_540_987.t3 VDD.t19 pfet_03v3 ad=0.3341p pd=1.805u as=0.5654p ps=3.45u w=1.285u l=0.28u
X3 a_830_145# AN Y VSS nfet_03v3 ad=0.52065p pd=3.23u as=0.3087p ps=2.01u w=1.02u l=0.28u
X4 a_540_987.t1 B.t4 VDD.t13 VDD.t12 pfet_03v3 ad=0.5654p pd=3.45u as=0.3341p ps=1.805u w=1.285u l=0.28u
X5 AN.t0 A.t1 VSS.t2 VSS.t0 nfet_03v3 ad=0.3087p pd=2.01u as=3.00385p ps=16.695u w=1.02u l=0.28u
X6 a_540_987.t2 AN.t3 Y.t3 VDD.t18 pfet_03v3 ad=0.3341p pd=1.805u as=0.3341p ps=1.805u w=1.285u l=0.28u
X7 Y.t1 BN.t5 a_1317_987.t2 VDD.t16 pfet_03v3 ad=0.3341p pd=1.805u as=0.3341p ps=1.805u w=1.285u l=0.28u
X8 BN.t0 B.t0 VSS.t4 VSS.t0 nfet_03v3 ad=0.3087p pd=2.01u as=4.00512p ps=22.26u w=1.02u l=0.28u
X9 BN.t1 B.t3 VDD.t9 VDD.t8 pfet_03v3 ad=0.3341p pd=1.805u as=0.5654p ps=3.45u w=1.285u l=0.28u
X10 a_1417_203r# A.t0 VSS.t1 VSS.t0 nfet_03v3 ad=0.3087p pd=2.015u as=3.00385p ps=16.695u w=1.02u l=0.28u
X11 a_1317_987.t3 BN.t4 Y.t2 VDD.t17 pfet_03v3 ad=0.5654p pd=3.45u as=0.3341p ps=1.805u w=1.285u l=0.28u
X12 Y.t0 B.t1 a_1417_203r# VSS.t3 nfet_03v3 ad=0.3087p pd=2.01u as=0.5148p ps=3.22u w=1.02u l=0.28u
X13 AN.t1 A.t5 VDD.t1 VDD.t0 pfet_03v3 ad=0.3341p pd=1.805u as=0.5654p ps=3.45u w=1.285u l=0.28u
X14 VDD.t11 B.t5 a_540_987.t0 VDD.t10 pfet_03v3 ad=0.3341p pd=1.805u as=0.3341p ps=1.805u w=1.285u l=0.28u
X15 VDD.t3 A.t3 a_1317_987.t0 VDD.t2 pfet_03v3 ad=0.3341p pd=1.805u as=0.5654p ps=3.45u w=1.285u l=0.28u
X16 a_830_145# BN.t3 VSS.t5 VSS.t0 nfet_03v3 ad=0.3087p pd=2.01u as=4.00512p ps=22.26u w=1.02u l=0.28u
X17 VDD.t15 B.t2 BN.t2 VDD.t14 pfet_03v3 ad=0.5654p pd=3.45u as=0.3341p ps=1.805u w=1.285u l=0.28u
R0 Y.t0 Y.n5 4.01391
R1 Y.t0 Y.n0 0.361235
R2 Y.n1 Y.n4 4.01391
R3 Y.n10 Y.n9 202.5
R4 Y.n25 Y.n20 202.5
R5 Y.n13 Y.n10 112.501
R6 Y.n3 Y.n20 116.52
R7 Y.n2 Y.n1 3.41354
R8 Y.n16 Y.n15 47.6267
R9 Y.n24 Y.n21 37.861
R10 Y.n14 Y.n6 34.7947
R11 Y.n19 Y.n18 30.8444
R12 Y.n19 Y.n8 30.8394
R13 Y.n1 Y.n22 30.2684
R14 Y.n23 Y.n21 28.2205
R15 Y.n13 Y.n11 22.5005
R16 Y Y.n19 17.3581
R17 Y.n6 Y.n11 17.1346
R18 Y Y.n7 15.5032
R19 Y.n16 Y.n11 11.777
R20 Y.n23 Y.n22 11.2505
R21 Y.n14 Y.n0 11.6304
R22 Y.n17 Y.n16 7.5005
R23 Y.n17 Y.n10 7.5005
R24 Y.t0 Y.n13 7.5005
R25 Y.n3 Y.n23 7.57091
R26 Y.n26 Y.n25 7.5005
R27 Y.n26 Y.n21 7.5005
R28 Y.n18 Y.t0 6.98326
R29 Y Y.n2 47.2396
R30 Y.n25 Y.n24 6.85139
R31 Y.t0 Y.n6 4.82859
R32 Y.n0 Y.n9 9.20397
R33 Y.n17 Y.n5 0.0778758
R34 Y.n9 Y.n5 116.513
R35 Y.n3 Y.n1 3.65029
R36 Y.n26 Y.n4 0.0778758
R37 Y.n20 Y.n4 116.513
R38 Y.n24 Y.n1 4.50901
R39 Y.n15 Y.n14 3.95439
R40 Y.n18 Y.n9 3.87981
R41 Y.n2 Y.n20 1.89685
R42 Y.n7 Y.t4 3.03552
R43 Y.n7 Y.t3 3.03552
R44 Y.n8 Y.t1 3.03552
R45 Y.n8 Y.t2 3.03552
R46 Y.n15 Y.n12 1.40041
R47 B.n13 B.n12 307.5
R48 B.n3 B.t3 81.5648
R49 B.n3 B.t2 78.2772
R50 B.n15 B.n14 74.3292
R51 B.n4 B.t5 63.81
R52 B.n4 B.t4 48.81
R53 B.n12 B.n11 20.7085
R54 B.n9 B.n2 58.83
R55 B.n2 B.n6 13.913
R56 B.n15 B.n11 12.0226
R57 B.n0 B.n4 10.8262
R58 B.n14 B.n12 8.78735
R59 B.n0 B.n9 8.48311
R60 B B.n3 7.89007
R61 B.n6 B.n5 7.67957
R62 B B.n16 7.5005
R63 B.t1 B.n7 7.5005
R64 B.n1 B.n7 7.23314
R65 B.n8 B.t1 7.18152
R66 B.n2 B.n1 4.86492
R67 B.n16 B.n10 6.52414
R68 B.n8 B.n5 6.23862
R69 B.n16 B.n15 5.49555
R70 B.n1 B.n8 5.18744
R71 B.t0 B.n13 4.9219
R72 B.n11 B.n10 3.94768
R73 B.n7 B.n6 2.67957
R74 B.n14 B.t0 2.28378
R75 B.n13 B.n10 1.62891
R76 B B.n0 1.18128
R77 B.n9 B.n5 1.03953
R78 A.n7 A.n6 307.5
R79 A.n11 A.n10 255
R80 A.n0 A.t4 81.5648
R81 A.n0 A.t5 78.2772
R82 A.n1 A.t2 64.0184
R83 A.n13 A.n10 60.0005
R84 A.n9 A.n8 57.2132
R85 A.n1 A.t3 48.6017
R86 A.n18 A.n1 38.7359
R87 A.n15 A.n14 23.75
R88 A.n6 A.n3 20.7085
R89 A.n14 A.n9 20.4747
R90 A.n16 A.n15 17.8219
R91 A.n15 A.n5 16.7862
R92 A.n16 A.n3 12.0226
R93 A.n12 A.n9 11.5184
R94 A.n10 A.n5 10.0005
R95 A.n8 A.n6 8.78735
R96 A A.t1 15.3422
R97 A.n16 A.n4 8.16652
R98 A A.n0 8.11407
R99 A.n11 A.n4 7.5005
R100 A.n12 A.n11 7.5005
R101 A.n14 A.n13 6.8553
R102 A.n17 A.n16 6.6005
R103 A.n17 A.n2 5.53225
R104 A.n18 A.n17 5.0005
R105 A.t0 A.n7 4.92276
R106 A.n13 A.n12 4.01836
R107 A.n3 A.n2 3.9392
R108 A.n5 A.n4 3.7505
R109 A A.n18 2.6194
R110 A.n8 A.t0 2.28378
R111 A.n7 A.n2 1.64162
R112 VDD.n70 VDD.n69 864.886
R113 VDD.n72 VDD.n71 164.505
R114 VDD.n41 VDD.n40 164.505
R115 VDD.n42 VDD.n39 164.505
R116 VDD.n46 VDD.n45 164.505
R117 VDD.n50 VDD.n35 164.505
R118 VDD.n52 VDD.n51 164.505
R119 VDD.n55 VDD.n31 164.505
R120 VDD.n57 VDD.n30 164.505
R121 VDD.n61 VDD.n60 164.505
R122 VDD.n62 VDD.n28 164.505
R123 VDD.n68 VDD.n24 164.505
R124 VDD.n60 VDD.t17 151.286
R125 VDD.n72 VDD.t0 141.005
R126 VDD.n39 VDD.t19 141.005
R127 VDD.n51 VDD.t12 141.005
R128 VDD.t14 VDD.n24 141.005
R129 VDD.n52 VDD.t2 130.722
R130 VDD.n56 VDD.t6 127.785
R131 VDD.n42 VDD.t4 117.504
R132 VDD.n47 VDD.t18 117.504
R133 VDD.n47 VDD.t10 117.504
R134 VDD.t8 VDD.n61 117.504
R135 VDD.t16 VDD.n56 107.222
R136 VDD.n57 VDD.t16 57.2832
R137 VDD.t4 VDD.n41 47.0017
R138 VDD.t18 VDD.n46 47.0017
R139 VDD.t10 VDD.n35 47.0017
R140 VDD.n62 VDD.t8 47.0017
R141 VDD.t6 VDD.n55 36.7202
R142 VDD.t2 VDD.n31 33.7826
R143 VDD.n40 VDD.t0 23.5011
R144 VDD.n45 VDD.t19 23.5011
R145 VDD.t12 VDD.n50 23.5011
R146 VDD.n28 VDD.t14 23.5011
R147 VDD.n66 VDD.n65 23.3338
R148 VDD.n74 VDD.n73 23.3338
R149 VDD.n73 VDD.n12 6.5635
R150 VDD.n38 VDD.n17 23.3338
R151 VDD.n43 VDD.n38 23.3338
R152 VDD.n6 VDD.n5 6.5635
R153 VDD.n44 VDD.n5 23.3338
R154 VDD.n7 VDD.n37 6.5635
R155 VDD.n48 VDD.n37 23.3338
R156 VDD.n48 VDD.n15 23.3338
R157 VDD.n13 VDD.n15 6.5635
R158 VDD.n49 VDD.n34 23.3338
R159 VDD.n3 VDD.n34 6.5635
R160 VDD.n53 VDD.n32 23.3338
R161 VDD.n14 VDD.n32 6.5635
R162 VDD.n54 VDD.n29 23.3338
R163 VDD.n58 VDD.n29 23.3338
R164 VDD.n9 VDD.n8 6.5635
R165 VDD.n59 VDD.n8 23.3338
R166 VDD.n10 VDD.n27 6.5635
R167 VDD.n63 VDD.n27 23.3338
R168 VDD.n63 VDD.n26 23.3338
R169 VDD.n11 VDD.n26 6.5635
R170 VDD.n67 VDD.n64 23.3338
R171 VDD.n20 VDD.n19 23.3338
R172 VDD.n2 VDD.n16 11.7458
R173 VDD.n4 VDD.n25 11.7458
R174 VDD VDD.n33 15.2628
R175 VDD VDD.n36 15.2628
R176 VDD VDD.n74 15.0005
R177 VDD.n73 VDD.n72 15.0005
R178 VDD.n12 VDD 4.21975
R179 VDD.n40 VDD.n17 15.0005
R180 VDD.n12 VDD.n17 6.5635
R181 VDD.n41 VDD.n38 15.0005
R182 VDD.n38 VDD 15.0005
R183 VDD.n43 VDD.n42 15.0005
R184 VDD.n6 VDD.n43 6.5635
R185 VDD.n39 VDD.n5 15.0005
R186 VDD VDD.n6 4.21975
R187 VDD.n45 VDD.n44 15.0005
R188 VDD.n44 VDD.n7 6.5635
R189 VDD.n46 VDD.n37 15.0005
R190 VDD.n7 VDD 4.21975
R191 VDD.n48 VDD.n47 15.0005
R192 VDD VDD.n48 15.0005
R193 VDD.n15 VDD.n35 15.0005
R194 VDD VDD.n13 4.21975
R195 VDD.n50 VDD.n49 15.0005
R196 VDD.n49 VDD.n13 6.5635
R197 VDD.n51 VDD.n34 15.0005
R198 VDD.n3 VDD 4.21975
R199 VDD.n53 VDD.n52 15.0005
R200 VDD.n3 VDD.n53 6.5635
R201 VDD.n32 VDD.n31 15.0005
R202 VDD VDD.n14 4.21975
R203 VDD.n55 VDD.n54 15.0005
R204 VDD.n54 VDD.n14 6.5635
R205 VDD.n56 VDD.n29 15.0005
R206 VDD.n29 VDD.n0 15.0005
R207 VDD.n58 VDD.n57 15.0005
R208 VDD.n9 VDD.n58 6.5635
R209 VDD.n30 VDD.n8 15.0005
R210 VDD.n0 VDD.n9 4.21975
R211 VDD.n60 VDD.n59 15.0005
R212 VDD.n59 VDD.n10 6.5635
R213 VDD.n61 VDD.n27 15.0005
R214 VDD.n10 VDD.n0 4.21975
R215 VDD.n63 VDD.n62 15.0005
R216 VDD.n0 VDD.n63 15.0005
R217 VDD.n28 VDD.n26 15.0005
R218 VDD.n0 VDD.n11 4.21975
R219 VDD.n64 VDD.n24 15.0005
R220 VDD.n64 VDD.n11 6.5635
R221 VDD.n68 VDD.n67 15.0005
R222 VDD.n67 VDD.n4 5.18282
R223 VDD.n69 VDD.n68 15.0005
R224 VDD.n65 VDD.n1 15.0005
R225 VDD.n0 VDD.n66 15.0005
R226 VDD.n4 VDD.n0 4.91009
R227 VDD.n2 VDD 4.21975
R228 VDD VDD.n20 15.0005
R229 VDD.n71 VDD.n19 15.0005
R230 VDD.n71 VDD.n70 15.0005
R231 VDD.n30 VDD.t17 13.2196
R232 VDD.n23 VDD.n22 13.0955
R233 VDD.n0 VDD.t15 10.895
R234 VDD VDD.t1 10.895
R235 VDD.n0 VDD.t9 10.8927
R236 VDD VDD.t5 10.8927
R237 VDD.n70 VDD.n21 6.64275
R238 VDD.n69 VDD.n22 6.64275
R239 VDD.n65 VDD.n23 6.5635
R240 VDD.n66 VDD.n25 6.5635
R241 VDD.n20 VDD.n18 6.5635
R242 VDD.n2 VDD.n18 13.1265
R243 VDD.n21 VDD.n19 6.53249
R244 VDD.n74 VDD.n16 5.18282
R245 VDD.n71 VDD.n16 4.91009
R246 VDD.n1 VDD.n22 4.52391
R247 VDD.n21 VDD 4.52391
R248 VDD.n68 VDD.n23 4.21975
R249 VDD.n68 VDD.n25 4.21975
R250 VDD.n71 VDD.n18 4.21975
R251 VDD.n33 VDD.t3 3.03552
R252 VDD.n33 VDD.t7 3.03552
R253 VDD.n36 VDD.t11 3.03552
R254 VDD.n36 VDD.t13 3.03552
R255 VDD VDD.n0 2.46877
R256 VDD.n0 VDD.n1 1.01277
R257 VSS.n38 VSS.n35 129.322
R258 VSS.n51 VSS.n26 129.078
R259 VSS.n41 VSS.n35 129.078
R260 VSS.t3 VSS.n26 70.3019
R261 VSS.n41 VSS.t0 56.4721
R262 VSS.n12 VSS.n11 13.0248
R263 VSS.n50 VSS.n22 6.5635
R264 VSS.n50 VSS.n24 23.3338
R265 VSS.n46 VSS.n9 23.3338
R266 VSS.n47 VSS.n9 23.3338
R267 VSS.n19 VSS.n30 13.1265
R268 VSS.n53 VSS.n25 23.3338
R269 VSS.n40 VSS.n18 23.3338
R270 VSS.n40 VSS.n36 23.3338
R271 VSS.n1 VSS.n42 6.5635
R272 VSS.n42 VSS.n34 23.3338
R273 VSS.n39 VSS.n38 21.1554
R274 VSS.n38 VSS.n37 21.1554
R275 VSS.n23 VSS.n3 6.12707
R276 VSS.n20 VSS.n15 6.1077
R277 VSS.n17 VSS.n31 12.9154
R278 VSS.n8 VSS.n7 16.9885
R279 VSS.n28 VSS.n2 12.7381
R280 VSS.n18 VSS.n25 15.8338
R281 VSS.n43 VSS.n10 15.8338
R282 VSS VSS.n53 15.0005
R283 VSS.n51 VSS.n25 15.0005
R284 VSS.n25 VSS 15.0005
R285 VSS VSS.n6 4.2944
R286 VSS.n7 VSS 15.0005
R287 VSS.n19 VSS 4.21975
R288 VSS VSS.n47 15.0005
R289 VSS.n51 VSS.n9 15.0005
R290 VSS VSS.n9 15.0005
R291 VSS VSS.n46 15.0005
R292 VSS.n51 VSS.n15 15.0005
R293 VSS VSS.n20 4.44765
R294 VSS.n17 VSS 2.84997
R295 VSS.n23 VSS.n29 12.6901
R296 VSS VSS.n2 2.9031
R297 VSS.n51 VSS.n3 15.0005
R298 VSS VSS.n23 4.43796
R299 VSS.n0 VSS.n24 15.0005
R300 VSS.n51 VSS.n50 15.0005
R301 VSS.n22 VSS.n0 4.21975
R302 VSS.n22 VSS.n32 13.1265
R303 VSS.n0 VSS.n21 4.21975
R304 VSS.n13 VSS.n0 2.84997
R305 VSS.n0 VSS.n44 15.0005
R306 VSS.n51 VSS.n10 15.0005
R307 VSS.n11 VSS.n10 6.5635
R308 VSS.n0 VSS.n11 4.21975
R309 VSS.n35 VSS.n34 15.0005
R310 VSS.n42 VSS.n41 15.0005
R311 VSS.n1 VSS.n0 4.21975
R312 VSS.n43 VSS.n26 15.0005
R313 VSS.n1 VSS.n43 6.5635
R314 VSS.n18 VSS.n26 15.0005
R315 VSS VSS.n18 15.0005
R316 VSS.n41 VSS.n40 15.0005
R317 VSS.n40 VSS 15.0005
R318 VSS.n36 VSS.n35 15.0005
R319 VSS.n14 VSS.t4 10.9505
R320 VSS.n16 VSS.t5 10.9505
R321 VSS.n4 VSS.t1 10.5005
R322 VSS.n8 VSS.t2 10.5005
R323 VSS.n8 VSS.n6 1.0609
R324 VSS.n17 VSS.n16 3.22754
R325 VSS.n4 VSS.n2 3.14785
R326 VSS.n14 VSS.n13 3.22754
R327 VSS.n4 VSS.n49 6.6005
R328 VSS.n8 VSS.n45 6.6005
R329 VSS.n21 VSS.n32 13.1265
R330 VSS.n20 VSS.n29 12.6707
R331 VSS.n47 VSS.n30 6.5635
R332 VSS.n37 VSS.n34 6.53249
R333 VSS.n39 VSS.n36 6.53249
R334 VSS.n53 VSS.n52 6.46182
R335 VSS.n13 VSS.n12 12.9154
R336 VSS.n19 VSS.n31 13.0248
R337 VSS.n52 VSS.n7 6.46182
R338 VSS.n21 VSS.n28 13.0069
R339 VSS.n14 VSS.n33 6.3005
R340 VSS.n16 VSS.n48 6.3005
R341 VSS.n46 VSS.n5 6.1077
R342 VSS.n44 VSS.n27 6.1077
R343 VSS.n24 VSS.n27 6.1077
R344 VSS.n6 VSS.n5 8.228
R345 VSS VSS.n39 4.52391
R346 VSS.n37 VSS.n0 4.52391
R347 VSS.n51 VSS.n5 4.44765
R348 VSS.n51 VSS.n27 4.44765
R349 VSS.n4 VSS.n3 4.4264
R350 VSS.n51 VSS.n28 4.27955
R351 VSS.n52 VSS.n51 4.27059
R352 VSS.n51 VSS.n31 4.27059
R353 VSS.n51 VSS.n12 4.27059
R354 VSS.n51 VSS.n30 4.21975
R355 VSS.n51 VSS.n29 4.21975
R356 VSS.n51 VSS.n32 4.21975
R357 VSS.n16 VSS.n15 3.55351
R358 VSS.n44 VSS.n14 3.55351
R359 VSS.t0 VSS.t3 2.30546
R360 VSS.n0 VSS 2.05623
R361 VSS.n0 VSS 1.26378
R362 VSS.n0 VSS 1.23254
R363 a_1317_987.n0 a_1317_987.t0 11.571
R364 a_1317_987.n0 a_1317_987.t3 11.5552
R365 a_1317_987.n1 a_1317_987.n0 7.5005
R366 a_1317_987.n1 a_1317_987.t2 3.03552
R367 a_1317_987.t1 a_1317_987.n1 3.03552
R368 a_540_987.t1 a_540_987.n1 11.571
R369 a_540_987.n1 a_540_987.t3 11.5552
R370 a_540_987.n1 a_540_987.n0 7.5005
R371 a_540_987.n0 a_540_987.t0 3.03552
R372 a_540_987.n0 a_540_987.t2 3.03552
R373 BN.n9 BN.t0 120.001
R374 BN.n2 BN.n8 115.718
R375 BN.n6 BN.t5 85.255
R376 BN.n11 BN.n10 67.4693
R377 BN.n6 BN.t4 40.0392
R378 BN.n10 BN.n9 34.8011
R379 BN.n0 BN.n6 25.472
R380 BN.n9 BN.n8 20.0898
R381 BN BN.n1 15.9259
R382 BN.n1 BN.n2 5.1751
R383 BN.n5 BN.n2 2.89242
R384 BN.n0 BN.n7 7.85546
R385 BN.n5 BN.n4 1.97827
R386 BN.n10 BN.n3 7.5005
R387 BN.t3 BN.n0 46.6148
R388 BN.n11 BN.n8 4.52242
R389 BN.n4 BN.t0 1.09191
R390 BN.n4 BN.n3 1.96464
R391 BN.n7 BN.t1 3.03552
R392 BN.n7 BN.t2 3.03552
R393 BN.n1 BN.t0 14.0052
R394 BN.n1 BN.n3 4.18614
R395 BN BN.n0 1.87115
R396 BN.n5 BN.n11 1.72383
R397 AN.n10 AN.t0 120.001
R398 AN.n1 AN.n9 115.718
R399 AN.n5 AN.t3 85.3938
R400 AN.n12 AN.n11 67.4693
R401 AN.n5 AN.t4 40.0194
R402 AN.n11 AN.n10 34.8011
R403 AN.n7 AN.n5 24.6149
R404 AN AN.n8 20.6639
R405 AN.n10 AN.n9 20.0898
R406 AN AN.n0 15.0005
R407 AN.n0 AN.n1 5.1751
R408 AN.n4 AN.n1 2.89242
R409 AN.n7 AN.n6 7.85546
R410 AN.n4 AN.n3 1.97827
R411 AN.n11 AN.n2 7.5005
R412 AN.n12 AN.n9 4.52242
R413 AN.n3 AN.t0 1.09191
R414 AN.n3 AN.n2 1.96464
R415 AN.n6 AN.t1 3.03552
R416 AN.n6 AN.t2 3.03552
R417 AN.n0 AN.t0 14.0052
R418 AN.n0 AN.n2 4.18614
R419 AN AN.n7 2.13189
R420 AN.n4 AN.n12 1.72383
C0 A a_1417_203r# 0.10385f
C1 A Y 0.68994f
C2 A BN 0.49112f
C3 A AN 0.77998f
C4 B Y 0.59487f
C5 BN B 0.88187f
C6 BN a_830_145# 0.10345f
C7 VDD Y 0.25414f
C8 VDD BN 0.89251f
C9 AN VDD 0.78101f
C10 a_1417_203r# Y 0.12804f
C11 A VDD 0.86514f
C12 BN Y 0.20677f
C13 AN Y 0.2813f
C14 VDD B 1.02671f
C15 Y VSS 1.83369f
C16 B VSS 1.43085f
C17 A VSS 1.80278f
C18 VDD VSS 7.79314f
C19 a_830_145# VSS 1.08243f
C20 BN VSS 1.01663f
C21 AN.t0 VSS 0.24941f
C22 AN.n5 VSS 0.1065f
C23 AN.t2 VSS 0.10209f
C24 AN.t1 VSS 0.10091f
C25 AN.n7 VSS 0.30468f
C26 AN.n8 VSS 0.3533f
C27 BN.n0 VSS 0.80585f
C28 BN.n6 VSS 0.12353f
C29 BN.t2 VSS 0.10156f
C30 BN.t1 VSS 0.10261f
C31 BN.n10 VSS 0.11471f
C32 a_540_987.t3 VSS 0.17753f
C33 a_540_987.n1 VSS 0.42915f
C34 a_540_987.t1 VSS 0.18589f
C35 a_1317_987.t2 VSS 0.11146f
C36 a_1317_987.t3 VSS 0.19255f
C37 a_1317_987.t0 VSS 0.19876f
C38 a_1317_987.n0 VSS 0.4507f
C39 a_1317_987.t1 VSS 0.10884f
C40 VSS.t2 VSS 0.23495f
C41 VSS.t5 VSS 0.36086f
C42 VDD.n0 VSS 0.23491f
C43 VDD.n24 VSS 0.12444f
C44 VDD.n39 VSS 0.12444f
C45 VDD.n42 VSS 0.11487f
C46 VDD.n51 VSS 0.12444f
C47 VDD.n52 VSS 0.12025f
C48 VDD.n60 VSS 0.12863f
C49 VDD.n61 VSS 0.11487f
C50 VDD.n68 VSS 0.20102f
C51 VDD.n71 VSS 0.22495f
C52 VDD.n72 VSS 0.12444f
C53 A.n0 VSS 0.17546f
C54 A.n1 VSS 0.29571f
C55 A.n8 VSS 0.12069f
C56 A.n9 VSS 0.13852f
C57 A.n18 VSS 0.4217f
C58 B.n0 VSS 0.49321f
C59 B.n2 VSS 0.21345f
C60 B.n3 VSS 0.15262f
C61 B.n4 VSS 0.20295f
C62 B.n9 VSS 0.19508f
C63 B.n14 VSS 0.14586f
C64 B.n15 VSS 0.2527f
C65 Y.n2 VSS 0.11633f
C66 Y.t1 VSS 0.10448f
C67 Y.n8 VSS 0.12828f
C68 Y.n19 VSS 0.4452f
.ends
