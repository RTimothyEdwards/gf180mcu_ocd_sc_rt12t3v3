* NGSPICE file created from gf180mcu_ocd_sc_rt12t3v3__decap_4.ext - technology: gf180mcuD

.subckt gf180mcu_ocd_sc_rt12t3v3__decap_4 VDD VSS
X0 a_146_799# a_56_147.t1 VSS.t1 VSS.t0 nfet_03v3 ad=0.35p pd=2.15u as=3.935p ps=20.89u w=1.09u l=0.28u
X1 a_56_147.t0 a_146_799# VDD.t1 VDD.t0 pfet_03v3 ad=0.9178p pd=4.57u as=4.38315p ps=21.8u w=1.765u l=0.53u
R0 VDD.n19 VDD.n18 195.548
R1 VDD.n20 VDD.n19 194.22
R2 VDD.n15 VDD.n7 194.22
R3 VDD.n24 VDD.n7 194.22
R4 VDD.n20 VDD.t0 102.312
R5 VDD.n15 VDD.t0 91.908
R6 VDD.n21 VDD.n11 23.3338
R7 VDD.n21 VDD.n9 23.3338
R8 VDD.n22 VDD.n2 6.5635
R9 VDD.n8 VDD.n4 23.3338
R10 VDD.n23 VDD.n3 6.5635
R11 VDD.n18 VDD.n10 18.9873
R12 VDD.n18 VDD.n17 18.948
R13 VDD.n12 VDD.n0 17.8728
R14 VDD.n16 VDD.n5 17.8728
R15 VDD.n23 VDD.n22 15.8338
R16 VDD.n26 VDD.n5 15.2487
R17 VDD VDD.n26 15.0005
R18 VDD VDD.n4 15.0005
R19 VDD.n1 VDD.n8 15.0005
R20 VDD.n24 VDD.n23 15.0005
R21 VDD.n3 VDD.n1 4.21975
R22 VDD.n16 VDD.n15 15.0005
R23 VDD VDD.n16 15.0005
R24 VDD.n7 VDD.n5 15.0005
R25 VDD.n5 VDD 15.0005
R26 VDD.n20 VDD.n0 15.0005
R27 VDD VDD.n0 15.0005
R28 VDD.n19 VDD.n12 15.0005
R29 VDD.n19 VDD.n11 15.0005
R30 VDD.n21 VDD.n20 15.0005
R31 VDD.n1 VDD.n21 15.0005
R32 VDD.n15 VDD.n9 15.0005
R33 VDD.n2 VDD.n9 6.5635
R34 VDD.n22 VDD.n7 15.0005
R35 VDD.n2 VDD.n1 4.21975
R36 VDD.n14 VDD.n0 9.41539
R37 VDD.n16 VDD.n14 8.45795
R38 VDD.n26 VDD.n25 6.5635
R39 VDD.n8 VDD.n6 6.5635
R40 VDD.n25 VDD.n4 6.5635
R41 VDD.n3 VDD.n6 13.1265
R42 VDD.n11 VDD.n10 6.53249
R43 VDD.n17 VDD.n12 6.49379
R44 VDD.n13 VDD 5.4685
R45 VDD.n17 VDD 4.54343
R46 VDD.n1 VDD.n10 4.52391
R47 VDD.n25 VDD.n24 4.21975
R48 VDD.n24 VDD.n6 4.21975
R49 VDD.n13 VDD.t1 2.21013
R50 VDD.n1 VDD 1.63677
R51 VDD.n14 VDD.n13 1.53024
R52 VSS.n13 VSS.n10 527.155
R53 VSS.n20 VSS.n6 526.013
R54 VSS.n16 VSS.n10 526.013
R55 VSS.t0 VSS.n6 295.882
R56 VSS.n16 VSS.t0 230.131
R57 VSS.n4 VSS.n17 6.5635
R58 VSS.n17 VSS.n9 23.3338
R59 VSS.n15 VSS.n5 23.3338
R60 VSS.n15 VSS.n11 23.3338
R61 VSS.n2 VSS.n3 2.60236
R62 VSS.n2 VSS.n1 20.2415
R63 VSS.n13 VSS.n12 19.3582
R64 VSS.n14 VSS.n13 19.3582
R65 VSS.n19 VSS.n18 15.8338
R66 VSS.n22 VSS.n5 15.8338
R67 VSS VSS.n19 15.0005
R68 VSS.n18 VSS.n6 15.0005
R69 VSS.n18 VSS.n4 6.5635
R70 VSS.n17 VSS.n16 15.0005
R71 VSS.n4 VSS.n0 4.21975
R72 VSS.n10 VSS.n9 15.0005
R73 VSS.n1 VSS 15.0005
R74 VSS.n20 VSS.n2 15.0005
R75 VSS VSS.n22 15.0005
R76 VSS.n11 VSS.n10 15.0005
R77 VSS.n16 VSS.n15 15.0005
R78 VSS.n15 VSS 15.0005
R79 VSS.n6 VSS.n5 15.0005
R80 VSS.n5 VSS 15.0005
R81 VSS.n2 VSS.t1 11.6981
R82 VSS.n2 VSS.n8 6.6005
R83 VSS.n12 VSS.n9 6.53249
R84 VSS.n14 VSS.n11 6.53249
R85 VSS.n19 VSS.n7 6.51076
R86 VSS.n21 VSS.n1 6.51076
R87 VSS.n3 VSS.n7 14.0194
R88 VSS.n22 VSS.n21 6.51076
R89 VSS.n3 VSS 1.92879
R90 VSS.n12 VSS.n0 4.52391
R91 VSS VSS.n14 4.52391
R92 VSS.n20 VSS.n7 4.24612
R93 VSS.n21 VSS.n20 4.24612
R94 VSS VSS.n0 1.01943
R95 a_56_147.t0 a_56_147.t1 20.5525
C0 VDD a_146_799# 0.33114f
C1 VDD VSS 1.9757f
C2 a_56_147.t0 VSS 0.41154f
C3 VSS.t1 VSS 0.15803f
C4 VDD.t1 VSS 0.21337f
C5 VDD.n18 VSS 0.10028f
.ends
