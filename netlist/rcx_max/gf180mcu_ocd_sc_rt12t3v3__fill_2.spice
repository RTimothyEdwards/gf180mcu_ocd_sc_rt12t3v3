* NGSPICE file created from gf180mcu_ocd_sc_rt12t3v3__fill_2.ext - technology: gf180mcuD

.subckt gf180mcu_ocd_sc_rt12t3v3__fill_2 VDD VSS
R0 VDD.n15 VDD.n14 289.599
R1 VDD.n16 VDD.n15 287.18
R2 VDD.n16 VDD.n5 287.18
R3 VDD.n19 VDD.n5 287.18
R4 VDD.n20 VDD.n19 287.18
R5 VDD.n17 VDD.n8 23.3338
R6 VDD.n17 VDD.n0 6.5635
R7 VDD.n18 VDD.n6 23.3338
R8 VDD.n21 VDD.n3 23.3338
R9 VDD.n10 VDD.n9 23.3338
R10 VDD.n11 VDD.n9 23.3338
R11 VDD.n11 VDD.n2 23.3338
R12 VDD.n14 VDD.n13 16.8081
R13 VDD.n14 VDD.n7 16.8081
R14 VDD.n21 VDD.n2 15.8338
R15 VDD.n21 VDD.n20 15.0005
R16 VDD VDD.n21 15.0005
R17 VDD.n3 VDD 15.0005
R18 VDD VDD.n1 4.91009
R19 VDD.n15 VDD.n8 15.0005
R20 VDD.n17 VDD.n16 15.0005
R21 VDD VDD.n0 4.21975
R22 VDD.n6 VDD.n5 15.0005
R23 VDD.n0 VDD.n6 6.5635
R24 VDD.n19 VDD.n18 15.0005
R25 VDD.n18 VDD.n1 5.18282
R26 VDD.n19 VDD.n2 15.0005
R27 VDD.n2 VDD 15.0005
R28 VDD.n11 VDD.n5 15.0005
R29 VDD VDD.n11 15.0005
R30 VDD.n16 VDD.n9 15.0005
R31 VDD.n12 VDD.n9 15.0005
R32 VDD.n15 VDD.n10 15.0005
R33 VDD.n1 VDD.n4 11.7458
R34 VDD.n4 VDD.n3 6.5635
R35 VDD.n13 VDD.n10 6.53249
R36 VDD.n8 VDD.n7 6.53249
R37 VDD VDD.n7 4.52391
R38 VDD.n13 VDD.n12 4.52391
R39 VDD.n20 VDD.n4 4.21975
R40 VDD.n12 VDD 1.44263
R41 VSS.n9 VSS.n7 779.644
R42 VSS.n15 VSS.n3 777.779
R43 VSS.n12 VSS.n3 777.779
R44 VSS.n12 VSS.n7 777.779
R45 VSS.n16 VSS.n2 23.3338
R46 VSS.n11 VSS.n1 23.3338
R47 VSS.n11 VSS.n8 23.3338
R48 VSS.n13 VSS.n4 23.3338
R49 VSS.n13 VSS.n6 23.3338
R50 VSS.n10 VSS.n9 17.9109
R51 VSS.n9 VSS.n5 17.9109
R52 VSS.n16 VSS.n1 15.8338
R53 VSS.n14 VSS.n0 11.7458
R54 VSS.n0 VSS 4.91009
R55 VSS.n2 VSS 15.0005
R56 VSS.n16 VSS.n15 15.0005
R57 VSS VSS.n16 15.0005
R58 VSS.n3 VSS.n1 15.0005
R59 VSS.n1 VSS 15.0005
R60 VSS.n12 VSS.n11 15.0005
R61 VSS.n11 VSS 15.0005
R62 VSS.n8 VSS.n7 15.0005
R63 VSS.n7 VSS.n6 15.0005
R64 VSS.n13 VSS.n12 15.0005
R65 VSS VSS.n13 15.0005
R66 VSS.n4 VSS.n3 15.0005
R67 VSS.n0 VSS.n4 5.18282
R68 VSS.n14 VSS.n2 6.5635
R69 VSS.n10 VSS.n8 6.53249
R70 VSS.n6 VSS.n5 6.53249
R71 VSS VSS.n10 5.45961
R72 VSS VSS.n5 4.52391
R73 VSS.n15 VSS.n14 4.21975
C0 VDD VSS 1.4111f
.ends
