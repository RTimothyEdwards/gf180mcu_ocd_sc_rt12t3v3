* NGSPICE file created from gf180mcu_ocd_sc_rt12t3v3__nand2_1.ext - technology: gf180mcuD

.subckt gf180mcu_ocd_sc_rt12t3v3__nand2_1 A B Y VDD VSS
X0 Y.t0 A.t0 a_193_203r# VSS.t0 nfet_03v3 ad=0.3087p pd=2.01u as=0.52065p ps=3.23u w=1.02u l=0.28u
X1 VDD.t7 B.t1 Y.t3 VDD.t6 pfet_03v3 ad=0.3341p pd=1.805u as=0.3341p ps=1.805u w=1.285u l=0.28u
X2 Y.t1 A.t2 VDD.t1 VDD.t0 pfet_03v3 ad=0.3341p pd=1.805u as=0.3341p ps=1.805u w=1.285u l=0.28u
X3 Y.t2 B.t2 VDD.t5 VDD.t4 pfet_03v3 ad=0.3341p pd=1.805u as=0.5654p ps=3.45u w=1.285u l=0.28u
X4 VDD.t3 A.t1 Y.t4 VDD.t2 pfet_03v3 ad=0.5654p pd=3.45u as=0.3341p ps=1.805u w=1.285u l=0.28u
X5 a_193_203r# B.t0 VSS.t2 VSS.t1 nfet_03v3 ad=0.3087p pd=2.01u as=5.19535p ps=29.85u w=1.02u l=0.28u
R0 Y.n11 Y.n7 210
R1 Y.n14 Y.n4 202.5
R2 Y.n7 Y.n4 112.501
R3 Y.n15 Y.n14 112.501
R4 Y.n8 Y.n6 35.0626
R5 Y.n11 Y.n10 31.9491
R6 Y.n12 Y.n11 22.7684
R7 Y.n15 Y.n13 22.5005
R8 Y.n13 Y.n6 17.1346
R9 Y.n16 Y.t0 15.2591
R10 Y Y.n16 15.1606
R11 Y.n13 Y.n12 11.777
R12 Y.n3 Y.n2 8.36867
R13 Y.n3 Y.n1 7.64972
R14 Y.n8 Y.n0 10.8735
R15 Y.n12 Y.n5 7.5005
R16 Y.n14 Y.n5 7.5005
R17 Y.t0 Y.n15 7.5005
R18 Y.t0 Y.n0 0.489634
R19 Y.t0 Y.n6 4.82859
R20 Y.t0 Y.n5 4.42579
R21 Y.n7 Y.n5 4.16717
R22 Y.n16 Y.n4 3.87981
R23 Y.n0 Y.n4 9.25828
R24 Y.n2 Y.t2 3.03552
R25 Y.n2 Y.t3 3.03552
R26 Y.n1 Y.t1 3.03552
R27 Y.n1 Y.t4 3.03552
R28 Y.n10 Y.n9 2.72827
R29 Y.n10 Y.n8 2.38736
R30 Y Y.n3 1.73572
R31 A.n5 A.t1 82.5005
R32 A.n3 A.n1 48.7619
R33 A.n5 A.t2 39.6434
R34 A A.n5 18.5195
R35 A.n4 A.n1 54.5094
R36 A.n1 A.n0 7.73582
R37 A A.n4 10.0305
R38 A.n3 A.n2 8.31572
R39 A.t0 A.n3 7.5005
R40 A.n0 A.n2 9.25248
R41 A.n4 A.n2 3.43863
R42 A.n0 A.t0 1.34655
R43 B.n0 B.t1 82.5005
R44 B.n0 B.t2 39.6434
R45 B B.n0 18.7416
R46 B B.t0 14.1269
R47 VDD.n32 VDD.n31 292.159
R48 VDD.n34 VDD.n33 164.505
R49 VDD.n24 VDD.n22 164.505
R50 VDD.n26 VDD.n21 164.505
R51 VDD.n30 VDD.n16 164.505
R52 VDD.n34 VDD.t4 141.005
R53 VDD.t2 VDD.n16 141.005
R54 VDD.n25 VDD.t6 117.504
R55 VDD.t0 VDD.n25 117.504
R56 VDD.t6 VDD.n24 47.0017
R57 VDD.n26 VDD.t0 47.0017
R58 VDD.n22 VDD.t4 23.5011
R59 VDD.n21 VDD.t2 23.5011
R60 VDD.n2 VDD.n15 13.1265
R61 VDD.n36 VDD.n35 23.3338
R62 VDD.n35 VDD.n6 6.5635
R63 VDD.n23 VDD.n8 23.3338
R64 VDD.n4 VDD.n20 6.5635
R65 VDD.n27 VDD.n20 23.3338
R66 VDD.n27 VDD.n18 23.3338
R67 VDD.n5 VDD.n18 6.5635
R68 VDD.n29 VDD.n28 23.3338
R69 VDD.n13 VDD.n10 23.3338
R70 VDD.n12 VDD.n11 23.3338
R71 VDD.n3 VDD.n17 11.7458
R72 VDD.n1 VDD.n19 15.256
R73 VDD VDD.n36 15.0005
R74 VDD.n35 VDD.n34 15.0005
R75 VDD.n6 VDD 4.21975
R76 VDD.n22 VDD.n8 15.0005
R77 VDD.n6 VDD.n8 6.5635
R78 VDD.n24 VDD.n23 15.0005
R79 VDD.n23 VDD.n4 6.5635
R80 VDD.n25 VDD.n20 15.0005
R81 VDD.n4 VDD.n1 4.21975
R82 VDD.n27 VDD.n26 15.0005
R83 VDD.n1 VDD.n27 15.0005
R84 VDD.n21 VDD.n18 15.0005
R85 VDD.n1 VDD.n5 4.21975
R86 VDD.n28 VDD.n16 15.0005
R87 VDD.n28 VDD.n5 6.5635
R88 VDD.n30 VDD.n29 15.0005
R89 VDD.n29 VDD.n3 5.18282
R90 VDD.n31 VDD.n30 15.0005
R91 VDD.n2 VDD.n1 4.21975
R92 VDD.n3 VDD.n1 4.91009
R93 VDD.n11 VDD 15.0005
R94 VDD VDD.n12 15.0005
R95 VDD VDD.n13 15.0005
R96 VDD.n33 VDD.n10 15.0005
R97 VDD.n33 VDD.n32 15.0005
R98 VDD.n15 VDD.n0 13.0955
R99 VDD.n1 VDD.t3 10.895
R100 VDD VDD.t5 10.895
R101 VDD.n32 VDD.n14 6.64275
R102 VDD.n31 VDD.n0 6.64275
R103 VDD.n2 VDD.n17 13.1265
R104 VDD.n13 VDD.n9 6.5635
R105 VDD.n12 VDD.n9 6.5635
R106 VDD.n14 VDD.n10 6.53249
R107 VDD.n11 VDD.n7 5.18282
R108 VDD.n36 VDD.n7 5.18282
R109 VDD.n33 VDD.n7 4.91009
R110 VDD.n1 VDD.n0 4.52391
R111 VDD.n14 VDD 4.52391
R112 VDD.n30 VDD.n15 4.21975
R113 VDD.n30 VDD.n17 4.21975
R114 VDD.n33 VDD.n9 4.21975
R115 VDD.n19 VDD.t7 3.03552
R116 VDD.n19 VDD.t1 3.03552
R117 VDD.n1 VDD 2.02503
R118 VSS.n32 VSS.n31 513.399
R119 VSS.n18 VSS.n17 513.399
R120 VSS.n18 VSS.n15 513.399
R121 VSS.n21 VSS.n15 513.399
R122 VSS.n23 VSS.n22 513.399
R123 VSS.n23 VSS.n13 513.399
R124 VSS.n22 VSS.t0 467.56
R125 VSS.n29 VSS.n28 319.659
R126 VSS.n32 VSS.t1 316.291
R127 VSS.n17 VSS.t1 197.109
R128 VSS.t0 VSS.n21 45.8397
R129 VSS.n20 VSS.n7 23.3338
R130 VSS.n9 VSS.n14 6.5635
R131 VSS.n24 VSS.n14 23.3338
R132 VSS.n11 VSS.n10 6.5635
R133 VSS.n33 VSS.n12 23.3338
R134 VSS.n19 VSS.n7 22.3675
R135 VSS.n33 VSS.n2 20.9317
R136 VSS.n8 VSS.n12 15.8338
R137 VSS.n25 VSS.n10 15.8338
R138 VSS VSS.n29 15.2537
R139 VSS.n28 VSS.n0 15.2537
R140 VSS.n33 VSS.n32 15.0005
R141 VSS VSS.n33 15.0005
R142 VSS.n31 VSS.n12 15.0005
R143 VSS.n12 VSS 15.0005
R144 VSS.n19 VSS.n18 15.0005
R145 VSS VSS.n1 3.01553
R146 VSS.n17 VSS.n2 15.0005
R147 VSS.n2 VSS 15.0005
R148 VSS.n10 VSS.n13 15.0005
R149 VSS.n0 VSS.n11 4.21975
R150 VSS.n24 VSS.n23 15.0005
R151 VSS.n11 VSS.n24 6.5635
R152 VSS.n22 VSS.n14 15.0005
R153 VSS.n9 VSS.n0 4.21975
R154 VSS.n21 VSS.n20 15.0005
R155 VSS.n20 VSS.n9 6.5635
R156 VSS.n7 VSS.n15 15.0005
R157 VSS VSS.n7 15.0005
R158 VSS.n6 VSS.n0 4.21975
R159 VSS.n26 VSS.n6 13.1265
R160 VSS.n25 VSS.n0 15.0005
R161 VSS VSS.n8 15.0005
R162 VSS VSS.n5 4.21975
R163 VSS.n19 VSS.n1 5.95742
R164 VSS.n3 VSS.t2 10.5005
R165 VSS.n3 VSS.n1 2.97921
R166 VSS.n3 VSS.n16 6.6005
R167 VSS.n29 VSS.n4 6.5635
R168 VSS.n28 VSS.n27 6.5635
R169 VSS.n30 VSS.n8 6.5635
R170 VSS.n30 VSS.n5 13.1265
R171 VSS.n5 VSS.n4 13.1265
R172 VSS.n26 VSS.n25 6.5635
R173 VSS.n27 VSS.n6 13.1265
R174 VSS.n3 VSS.n2 5.87219
R175 VSS.n27 VSS.n13 4.21975
R176 VSS.n26 VSS.n13 4.21975
R177 VSS.n31 VSS.n30 4.21975
R178 VSS.n31 VSS.n4 4.21975
R179 VSS.n0 VSS 1.15252
C0 VDD B 0.445f
C1 A VDD 0.39707f
C2 Y VDD 0.48004f
C3 a_193_203r# B 0.10485f
C4 Y A 0.3705f
C5 Y VSS 0.37778f
C6 A VSS 0.77834f
C7 B VSS 0.91986f
C8 VDD VSS 3.15057f
C9 a_193_203r# VSS 0.19329f
C10 VSS.t2 VSS 0.10828f
C11 VDD.n1 VSS 0.12012f
C12 VDD.n30 VSS 0.13909f
C13 VDD.n33 VSS 0.13909f
C14 A.n1 VSS 0.17184f
C15 A.n4 VSS 0.1442f
C16 Y.n3 VSS 0.24781f
.ends
