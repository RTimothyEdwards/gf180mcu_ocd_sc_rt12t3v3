* NGSPICE file created from gf180mcu_ocd_sc_rt12t3v3__tinv_1.ext - technology: gf180mcuD

.subckt gf180mcu_ocd_sc_rt12t3v3__tinv_1 A EN Y VDD VSS
X0 Y.t1 EN.t1 a_181_203r# VSS.t0 nfet_03v3 ad=0.3087p pd=2.01u as=0.52065p ps=3.23u w=1.02u l=0.28u
X1 a_92_987.t1 A.t1 VDD.t5 VDD.t4 pfet_03v3 ad=0.3341p pd=1.805u as=0.3341p ps=1.805u w=1.285u l=0.28u
X2 VDD.t3 EN.t2 EN_BAR.t1 VDD.t2 pfet_03v3 ad=0.5654p pd=3.45u as=0.3341p ps=1.805u w=1.285u l=0.28u
X3 Y.t2 EN_BAR.t4 a_92_987.t3 VDD.t9 pfet_03v3 ad=0.3341p pd=1.805u as=0.3341p ps=1.805u w=1.285u l=0.28u
X4 EN_BAR.t2 EN.t0 VSS.t2 VSS.t1 nfet_03v3 ad=0.3087p pd=2.01u as=3.57195p ps=19.96u w=1.02u l=0.28u
X5 VDD.t7 A.t2 a_92_987.t0 VDD.t6 pfet_03v3 ad=0.3341p pd=1.805u as=0.5654p ps=3.45u w=1.285u l=0.28u
X6 a_92_987.t2 EN_BAR.t3 Y.t0 VDD.t8 pfet_03v3 ad=0.5654p pd=3.45u as=0.3341p ps=1.805u w=1.285u l=0.28u
X7 EN_BAR.t0 EN.t3 VDD.t1 VDD.t0 pfet_03v3 ad=0.3341p pd=1.805u as=0.5654p ps=3.45u w=1.285u l=0.28u
X8 a_181_203r# A.t0 VSS.t4 VSS.t3 nfet_03v3 ad=0.3087p pd=2.01u as=3.57195p ps=19.96u w=1.02u l=0.28u
R0 Y.n9 Y.n5 210
R1 Y.n12 Y.n2 202.5
R2 Y.n5 Y.n2 112.501
R3 Y.n13 Y.n12 112.501
R4 Y.n6 Y.n4 35.0626
R5 Y.n9 Y.n8 31.9491
R6 Y.n10 Y.n9 22.7684
R7 Y.n13 Y.n11 22.5005
R8 Y.n11 Y.n4 17.1346
R9 Y Y.n1 15.2775
R10 Y.n14 Y.t1 15.2591
R11 Y Y.n14 15.0977
R12 Y.n11 Y.n10 11.777
R13 Y.n6 Y.n0 10.8735
R14 Y.n10 Y.n3 7.5005
R15 Y.n12 Y.n3 7.5005
R16 Y.t1 Y.n13 7.5005
R17 Y.t1 Y.n0 0.489634
R18 Y.t1 Y.n4 4.82859
R19 Y.t1 Y.n3 4.42579
R20 Y.n5 Y.n3 4.16717
R21 Y.n14 Y.n2 3.87981
R22 Y.n0 Y.n2 9.25828
R23 Y.n1 Y.t2 3.03552
R24 Y.n1 Y.t0 3.03552
R25 Y.n8 Y.n7 2.72827
R26 Y.n8 Y.n6 2.38736
R27 EN.n13 EN.n12 307.5
R28 EN.n5 EN.t3 103.684
R29 EN.n15 EN.n14 74.3292
R30 EN.n5 EN.t2 63.4826
R31 EN.n7 EN.n6 22.5653
R32 EN.n12 EN.n11 20.7085
R33 EN.n9 EN.n8 19.5144
R34 EN.n8 EN.n6 17.9614
R35 EN EN.n5 15.8889
R36 EN EN.n9 15.776
R37 EN.n6 EN.n4 54.6204
R38 EN.n3 EN.n7 13.152
R39 EN.t1 EN.n4 5.75103
R40 EN.n9 EN.n1 12.7556
R41 EN.n15 EN.n11 12.0226
R42 EN.t1 EN.n1 11.6568
R43 EN.n14 EN.n12 8.78735
R44 EN EN.n16 8.04598
R45 EN.n3 EN.n4 3.54477
R46 EN.n8 EN.n0 1.492
R47 EN.n2 EN.n0 2.99172
R48 EN.n16 EN.n10 6.52414
R49 EN.n16 EN.n15 5.49555
R50 EN.t0 EN.n13 4.9219
R51 EN.n11 EN.n10 3.94768
R52 EN.n7 EN.n0 3.87892
R53 EN.n14 EN.t0 2.28378
R54 EN.n13 EN.n10 1.62891
R55 EN.n2 EN.n3 7.80663
R56 EN.n2 EN.n1 1.6538
R57 A.n0 A.t1 64.0184
R58 A.n0 A.t2 48.6017
R59 A A.t0 12.1592
R60 A A.n0 8.44486
R61 VDD.n40 VDD.n39 444.887
R62 VDD.t6 VDD.n41 305.509
R63 VDD.n42 VDD.n11 164.505
R64 VDD.n29 VDD.n27 164.505
R65 VDD.n33 VDD.n32 164.505
R66 VDD.n34 VDD.n24 164.505
R67 VDD.n38 VDD.n20 164.505
R68 VDD.n32 VDD.t8 141.005
R69 VDD.t2 VDD.n20 141.005
R70 VDD.n28 VDD.t4 117.504
R71 VDD.t9 VDD.n28 117.504
R72 VDD.t0 VDD.n33 117.504
R73 VDD.t4 VDD.n11 47.0017
R74 VDD.n29 VDD.t9 47.0017
R75 VDD.n34 VDD.t0 47.0017
R76 VDD.n44 VDD.n43 46.6672
R77 VDD.n42 VDD.t6 23.5011
R78 VDD.n27 VDD.t8 23.5011
R79 VDD.n24 VDD.t2 23.5011
R80 VDD.n2 VDD.n19 13.1265
R81 VDD.n43 VDD.n8 6.5635
R82 VDD.n26 VDD.n9 23.3338
R83 VDD.n30 VDD.n26 23.3338
R84 VDD.n5 VDD.n4 6.5635
R85 VDD.n31 VDD.n4 23.3338
R86 VDD.n6 VDD.n23 6.5635
R87 VDD.n35 VDD.n23 23.3338
R88 VDD.n35 VDD.n22 23.3338
R89 VDD.n7 VDD.n22 6.5635
R90 VDD.n37 VDD.n36 23.3338
R91 VDD.n16 VDD.n13 23.3338
R92 VDD.n15 VDD.n14 23.3338
R93 VDD.n3 VDD.n21 11.7458
R94 VDD VDD.n25 15.2628
R95 VDD VDD.n44 15.0005
R96 VDD.n43 VDD.n42 15.0005
R97 VDD.n8 VDD 4.21975
R98 VDD.n11 VDD.n9 15.0005
R99 VDD.n8 VDD.n9 6.5635
R100 VDD.n28 VDD.n26 15.0005
R101 VDD.n26 VDD 15.0005
R102 VDD.n30 VDD.n29 15.0005
R103 VDD.n5 VDD.n30 6.5635
R104 VDD.n27 VDD.n4 15.0005
R105 VDD VDD.n5 4.21975
R106 VDD.n32 VDD.n31 15.0005
R107 VDD.n31 VDD.n6 6.5635
R108 VDD.n33 VDD.n23 15.0005
R109 VDD.n6 VDD 4.21975
R110 VDD.n35 VDD.n34 15.0005
R111 VDD VDD.n35 15.0005
R112 VDD.n24 VDD.n22 15.0005
R113 VDD VDD.n7 4.21975
R114 VDD.n36 VDD.n20 15.0005
R115 VDD.n36 VDD.n7 6.5635
R116 VDD.n38 VDD.n37 15.0005
R117 VDD.n37 VDD.n3 5.18282
R118 VDD.n39 VDD.n38 15.0005
R119 VDD.n2 VDD.n1 4.21975
R120 VDD.n3 VDD.n1 4.91009
R121 VDD.n14 VDD 15.0005
R122 VDD VDD.n15 15.0005
R123 VDD.n17 VDD.n16 15.0005
R124 VDD.n41 VDD.n13 15.0005
R125 VDD.n41 VDD.n40 15.0005
R126 VDD.n19 VDD.n0 13.0955
R127 VDD VDD.t3 10.895
R128 VDD VDD.t1 10.8927
R129 VDD.n40 VDD.n18 6.64275
R130 VDD.n39 VDD.n0 6.64275
R131 VDD.n2 VDD.n21 13.1265
R132 VDD.n16 VDD.n12 6.5635
R133 VDD.n15 VDD.n12 6.5635
R134 VDD.n18 VDD.n13 6.53249
R135 VDD.n14 VDD.n10 5.18282
R136 VDD.n44 VDD.n10 5.18282
R137 VDD.n41 VDD.n10 4.91009
R138 VDD.n1 VDD.n0 4.52391
R139 VDD.n18 VDD.n17 4.52391
R140 VDD.n38 VDD.n19 4.21975
R141 VDD.n38 VDD.n21 4.21975
R142 VDD.n41 VDD.n12 4.21975
R143 VDD.n25 VDD.t7 3.03552
R144 VDD.n25 VDD.t5 3.03552
R145 VDD VDD.n1 1.40103
R146 VDD.n17 VDD 1.01277
R147 VSS.n42 VSS.t3 774.683
R148 VSS.n24 VSS.n23 513.399
R149 VSS.n24 VSS.n22 513.399
R150 VSS.n28 VSS.n27 513.399
R151 VSS.n29 VSS.n28 513.399
R152 VSS.n29 VSS.n19 513.399
R153 VSS.n33 VSS.n32 513.399
R154 VSS.n34 VSS.n33 513.399
R155 VSS.n34 VSS.n15 513.399
R156 VSS.n22 VSS.t0 504.231
R157 VSS.n40 VSS.n39 472.387
R158 VSS.n19 VSS.t1 261.284
R159 VSS.n23 VSS.t3 252.117
R160 VSS.n32 VSS.t1 252.117
R161 VSS.n43 VSS.n0 43.9337
R162 VSS.n35 VSS.n9 6.5635
R163 VSS.n26 VSS.n20 23.3338
R164 VSS.n26 VSS.n18 23.3338
R165 VSS.n30 VSS.n8 6.5635
R166 VSS.n30 VSS.n12 23.3338
R167 VSS.n35 VSS.n13 22.6988
R168 VSS.n25 VSS.n10 6.46182
R169 VSS.n31 VSS.n11 6.1077
R170 VSS.n4 VSS.n13 6.45409
R171 VSS.n25 VSS.n2 16.9885
R172 VSS.n43 VSS.n14 15.8338
R173 VSS.n36 VSS.n16 15.8338
R174 VSS VSS.n40 15.2537
R175 VSS.n39 VSS 15.2537
R176 VSS.n43 VSS.n42 15.0005
R177 VSS VSS.n43 15.0005
R178 VSS.n25 VSS.n24 15.0005
R179 VSS VSS.n10 4.27059
R180 VSS.n23 VSS.n0 15.0005
R181 VSS.n1 VSS 4.2944
R182 VSS.n19 VSS.n12 15.0005
R183 VSS.n11 VSS.n12 6.1077
R184 VSS.n30 VSS.n29 15.0005
R185 VSS VSS.n8 4.21975
R186 VSS.n28 VSS.n18 15.0005
R187 VSS.n18 VSS.n8 6.5635
R188 VSS.n27 VSS.n26 15.0005
R189 VSS.n26 VSS 15.0005
R190 VSS.n22 VSS.n20 15.0005
R191 VSS.n10 VSS.n20 6.46182
R192 VSS.n33 VSS.n13 15.0005
R193 VSS VSS.n4 2.84997
R194 VSS.n32 VSS.n31 15.0005
R195 VSS.n11 VSS 4.44765
R196 VSS.n16 VSS.n15 15.0005
R197 VSS.n9 VSS.n16 6.5635
R198 VSS.n35 VSS.n34 15.0005
R199 VSS VSS.n9 4.21975
R200 VSS.n7 VSS 4.21975
R201 VSS.n37 VSS.n7 13.1265
R202 VSS.n36 VSS 15.0005
R203 VSS.n14 VSS 15.0005
R204 VSS VSS.n6 4.21975
R205 VSS.n3 VSS.t2 10.9505
R206 VSS.n2 VSS.t4 10.5005
R207 VSS.n27 VSS.t0 9.16834
R208 VSS.n2 VSS.n1 1.0609
R209 VSS.n4 VSS.n3 3.22754
R210 VSS.n2 VSS.n21 6.6005
R211 VSS.n40 VSS.n5 6.5635
R212 VSS.n39 VSS.n38 6.5635
R213 VSS.n41 VSS.n14 6.5635
R214 VSS.n41 VSS.n6 13.1265
R215 VSS.n6 VSS.n5 13.1265
R216 VSS.n37 VSS.n36 6.5635
R217 VSS.n38 VSS.n7 13.1265
R218 VSS.n3 VSS.n17 6.3005
R219 VSS.n38 VSS.n15 4.21975
R220 VSS.n37 VSS.n15 4.21975
R221 VSS.n42 VSS.n41 4.21975
R222 VSS.n42 VSS.n5 4.21975
R223 VSS.n1 VSS.n0 2.1208
R224 VSS.n31 VSS.n3 3.55351
R225 a_92_987.n0 a_92_987.t0 11.571
R226 a_92_987.n0 a_92_987.t2 11.5552
R227 a_92_987.n1 a_92_987.n0 7.5005
R228 a_92_987.n1 a_92_987.t3 3.03552
R229 a_92_987.t1 a_92_987.n1 3.03552
R230 EN_BAR.n9 EN_BAR.t2 120.001
R231 EN_BAR.n1 EN_BAR.n8 115.718
R232 EN_BAR.n5 EN_BAR.t4 84.1989
R233 EN_BAR.n11 EN_BAR.n10 67.4693
R234 EN_BAR.n5 EN_BAR.t3 40.6314
R235 EN_BAR.n10 EN_BAR.n9 34.8011
R236 EN_BAR.n7 EN_BAR.n5 21.1032
R237 EN_BAR.n9 EN_BAR.n8 20.0898
R238 EN_BAR EN_BAR.n0 15.9259
R239 EN_BAR.n0 EN_BAR.n1 5.1751
R240 EN_BAR.n4 EN_BAR.n1 2.89242
R241 EN_BAR.n7 EN_BAR.n6 7.85546
R242 EN_BAR.n4 EN_BAR.n3 1.97827
R243 EN_BAR.n10 EN_BAR.n2 7.5005
R244 EN_BAR.n11 EN_BAR.n8 4.52242
R245 EN_BAR.n3 EN_BAR.t2 1.09191
R246 EN_BAR.n3 EN_BAR.n2 1.96464
R247 EN_BAR.n6 EN_BAR.t0 3.03552
R248 EN_BAR.n6 EN_BAR.t1 3.03552
R249 EN_BAR.n0 EN_BAR.t2 14.0052
R250 EN_BAR.n0 EN_BAR.n2 4.18614
R251 EN_BAR.n4 EN_BAR.n11 1.72383
R252 EN_BAR EN_BAR.n7 1.2065
C0 Y EN 0.1187f
C1 VDD EN_BAR 0.71848f
C2 EN_BAR EN 0.45223f
C3 VDD EN 0.51379f
C4 A a_181_203r# 0.10622f
C5 A VDD 0.46668f
C6 Y VSS 0.27964f
C7 EN VSS 1.23377f
C8 A VSS 0.97695f
C9 VDD VSS 4.51358f
C10 a_181_203r# VSS 0.20384f
C11 EN_BAR VSS 0.53547f
C12 EN_BAR.n7 VSS 0.29312f
C13 EN_BAR.n10 VSS 0.10252f
C14 a_92_987.t3 VSS 0.10181f
C15 a_92_987.t2 VSS 0.17968f
C16 a_92_987.t0 VSS 0.16782f
C17 a_92_987.n0 VSS 0.42576f
C18 VSS.t4 VSS 0.12215f
C19 VDD.n20 VSS 0.10703f
C20 VDD.n32 VSS 0.10703f
C21 VDD.n38 VSS 0.1729f
C22 VDD.n41 VSS 0.24288f
C23 VDD.t6 VSS 0.11527f
C24 EN.n4 VSS 0.10292f
C25 EN.n15 VSS 0.15293f
.ends
