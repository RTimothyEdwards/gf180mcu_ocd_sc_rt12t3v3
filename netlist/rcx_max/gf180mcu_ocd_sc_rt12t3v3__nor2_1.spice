* NGSPICE file created from gf180mcu_ocd_sc_rt12t3v3__nor2_1.ext - technology: gf180mcuD

.subckt gf180mcu_ocd_sc_rt12t3v3__nor2_1 A B Y VDD VSS
X0 a_92_987.t3 A.t1 VDD.t5 VDD.t4 pfet_03v3 ad=0.3341p pd=1.805u as=0.3341p ps=1.805u w=1.285u l=0.28u
X1 Y.t3 B.t0 VSS.t1 VSS.t0 nfet_03v3 ad=0.3087p pd=2.01u as=2.87915p ps=15.24u w=1.02u l=0.28u
X2 Y.t1 B.t2 a_92_987.t0 VDD.t0 pfet_03v3 ad=0.3341p pd=1.805u as=0.3341p ps=1.805u w=1.285u l=0.28u
X3 VDD.t3 A.t2 a_92_987.t2 VDD.t2 pfet_03v3 ad=0.3341p pd=1.805u as=0.5654p ps=3.45u w=1.285u l=0.28u
X4 a_92_987.t1 B.t1 Y.t2 VDD.t1 pfet_03v3 ad=0.5654p pd=3.45u as=0.3341p ps=1.805u w=1.285u l=0.28u
X5 Y.t0 A.t0 VSS.t3 VSS.t2 nfet_03v3 ad=0.3087p pd=2.01u as=2.87915p ps=15.24u w=1.02u l=0.28u
R0 Y.n11 Y.t0 120.001
R1 Y.n15 Y.t3 120.001
R2 Y.n2 Y.n10 115.718
R3 Y.n6 Y.n14 115.718
R4 Y.n13 Y.n12 67.4693
R5 Y.n17 Y.n16 67.4693
R6 Y.n16 Y.n15 40.8056
R7 Y.n12 Y.n11 34.8011
R8 Y.n11 Y.n10 20.0898
R9 Y.n15 Y.n14 20.0898
R10 Y Y.n18 16.9105
R11 Y Y.n1 15.4527
R12 Y Y.n0 15.3803
R13 Y.n0 Y.n2 5.1751
R14 Y.n1 Y.n6 5.1751
R15 Y.n5 Y.n2 2.89242
R16 Y.n9 Y.n6 2.89242
R17 Y.n5 Y.n4 1.97827
R18 Y.n12 Y.n3 7.5005
R19 Y.n9 Y.n8 1.97827
R20 Y.n16 Y.n7 7.5005
R21 Y.n13 Y.n10 4.52242
R22 Y.n17 Y.n14 4.52242
R23 Y.n4 Y.t0 1.09191
R24 Y.n8 Y.t3 1.09191
R25 Y.n4 Y.n3 1.96464
R26 Y.n8 Y.n7 1.96464
R27 Y.n18 Y.t1 3.03552
R28 Y.n18 Y.t2 3.03552
R29 Y.n0 Y.t0 14.0052
R30 Y.n1 Y.t3 14.0052
R31 Y.n1 Y.n7 4.18614
R32 Y.n0 Y.n3 4.18614
R33 Y.n9 Y.n17 1.72383
R34 Y.n5 Y.n13 1.72383
R35 B.n0 B.t2 82.5005
R36 B.n0 B.t1 39.6434
R37 B B.n0 29.2026
R38 B B.t0 17.4783
R39 A.n0 A.t1 82.5005
R40 A A.n0 43.1394
R41 A.n0 A.t2 39.6434
R42 A A.t0 14.3507
R43 VDD.n32 VDD.n31 292.159
R44 VDD.n34 VDD.n33 164.505
R45 VDD.n23 VDD.n20 164.505
R46 VDD.n25 VDD.n19 164.505
R47 VDD.n30 VDD.n16 164.505
R48 VDD.n34 VDD.t2 141.005
R49 VDD.t1 VDD.n16 141.005
R50 VDD.n24 VDD.t4 117.504
R51 VDD.t0 VDD.n24 117.504
R52 VDD.t4 VDD.n23 47.0017
R53 VDD.n25 VDD.t0 47.0017
R54 VDD.n20 VDD.t2 23.5011
R55 VDD.n19 VDD.t1 23.5011
R56 VDD.n2 VDD.n15 13.1265
R57 VDD.n36 VDD.n35 23.3338
R58 VDD.n35 VDD.n6 23.3338
R59 VDD.n7 VDD.n6 6.5635
R60 VDD.n22 VDD.n18 23.3338
R61 VDD.n26 VDD.n18 23.3338
R62 VDD.n4 VDD.n3 6.5635
R63 VDD.n27 VDD.n3 23.3338
R64 VDD.n29 VDD.n5 6.5635
R65 VDD.n13 VDD.n10 23.3338
R66 VDD.n12 VDD.n11 23.3338
R67 VDD.n29 VDD.n28 15.8338
R68 VDD VDD.n36 15.0005
R69 VDD.n35 VDD.n34 15.0005
R70 VDD.n35 VDD 15.0005
R71 VDD.n20 VDD.n6 15.0005
R72 VDD VDD.n7 4.21975
R73 VDD.n23 VDD.n22 15.0005
R74 VDD.n22 VDD.n7 6.5635
R75 VDD.n24 VDD.n18 15.0005
R76 VDD.n18 VDD.n0 15.0005
R77 VDD.n26 VDD.n25 15.0005
R78 VDD.n4 VDD.n26 6.5635
R79 VDD.n19 VDD.n3 15.0005
R80 VDD.n0 VDD.n4 4.21975
R81 VDD.n27 VDD.n16 15.0005
R82 VDD.n27 VDD.n5 6.5635
R83 VDD.n30 VDD.n29 15.0005
R84 VDD.n5 VDD.n0 4.21975
R85 VDD.n31 VDD.n30 15.0005
R86 VDD.n2 VDD.n0 4.21975
R87 VDD.n28 VDD.n0 15.0005
R88 VDD.n11 VDD 15.0005
R89 VDD VDD.n12 15.0005
R90 VDD VDD.n13 15.0005
R91 VDD.n33 VDD.n10 15.0005
R92 VDD.n33 VDD.n32 15.0005
R93 VDD.n15 VDD.n1 13.0955
R94 VDD VDD.n21 7.83511
R95 VDD.n32 VDD.n14 6.64275
R96 VDD.n31 VDD.n1 6.64275
R97 VDD.n28 VDD.n17 6.5635
R98 VDD.n2 VDD.n17 13.1265
R99 VDD.n13 VDD.n9 6.5635
R100 VDD.n12 VDD.n9 6.5635
R101 VDD.n14 VDD.n10 6.53249
R102 VDD.n11 VDD.n8 5.18282
R103 VDD.n36 VDD.n8 5.18282
R104 VDD.n33 VDD.n8 4.91009
R105 VDD.n0 VDD.n1 4.52391
R106 VDD.n14 VDD 4.52391
R107 VDD.n30 VDD.n15 4.21975
R108 VDD.n30 VDD.n17 4.21975
R109 VDD.n33 VDD.n9 4.21975
R110 VDD.n21 VDD.t3 3.03552
R111 VDD.n21 VDD.t5 3.03552
R112 VDD VDD.n0 2.02503
R113 VSS.n33 VSS.n32 513.399
R114 VSS.n20 VSS.n19 513.399
R115 VSS.n21 VSS.n20 513.399
R116 VSS.n21 VSS.n18 513.399
R117 VSS.n24 VSS.n23 513.399
R118 VSS.n24 VSS.n13 513.399
R119 VSS.n23 VSS.t0 325.459
R120 VSS.n33 VSS.t2 316.291
R121 VSS.n30 VSS.n29 309.659
R122 VSS.n19 VSS.t2 197.109
R123 VSS.n18 VSS.t0 187.941
R124 VSS.n34 VSS.n12 23.3338
R125 VSS.n22 VSS.n11 23.251
R126 VSS.n25 VSS.n10 6.53281
R127 VSS.n22 VSS.n17 22.3675
R128 VSS.n34 VSS.n2 20.9317
R129 VSS.n1 VSS.n11 7.67488
R130 VSS.n25 VSS.n0 19.88
R131 VSS.n9 VSS.n12 15.8338
R132 VSS.n26 VSS.n14 15.8338
R133 VSS.n7 VSS.n30 15.2537
R134 VSS.n29 VSS 15.2537
R135 VSS.n34 VSS.n33 15.0005
R136 VSS VSS.n34 15.0005
R137 VSS.n32 VSS.n12 15.0005
R138 VSS.n12 VSS 15.0005
R139 VSS.n20 VSS.n17 15.0005
R140 VSS.n4 VSS 3.01553
R141 VSS.n19 VSS.n2 15.0005
R142 VSS.n2 VSS 15.0005
R143 VSS.n18 VSS.n11 15.0005
R144 VSS VSS.n1 1.78457
R145 VSS.n22 VSS.n21 15.0005
R146 VSS VSS.n22 15.0005
R147 VSS.n23 VSS.n0 15.0005
R148 VSS.n14 VSS.n13 15.0005
R149 VSS.n10 VSS.n14 6.53281
R150 VSS.n25 VSS.n24 15.0005
R151 VSS VSS.n10 4.23509
R152 VSS.n8 VSS 4.21975
R153 VSS.n27 VSS.n8 13.1265
R154 VSS.n26 VSS 15.0005
R155 VSS VSS.n9 15.0005
R156 VSS.n7 VSS.n6 4.21975
R157 VSS.n17 VSS.n4 5.95742
R158 VSS.n0 VSS.t1 10.5005
R159 VSS.n3 VSS.t3 10.5005
R160 VSS.n4 VSS.n3 2.97921
R161 VSS.n1 VSS.n0 2.73081
R162 VSS.n0 VSS.n15 6.6005
R163 VSS.n3 VSS.n16 6.6005
R164 VSS.n30 VSS.n5 6.5635
R165 VSS.n29 VSS.n28 6.5635
R166 VSS.n31 VSS.n9 6.5635
R167 VSS.n31 VSS.n6 13.1265
R168 VSS.n6 VSS.n5 13.1265
R169 VSS.n27 VSS.n26 6.5635
R170 VSS.n28 VSS.n8 13.1265
R171 VSS.n3 VSS.n2 5.87219
R172 VSS.n28 VSS.n13 4.21975
R173 VSS.n27 VSS.n13 4.21975
R174 VSS.n32 VSS.n31 4.21975
R175 VSS.n32 VSS.n5 4.21975
R176 VSS.n7 VSS 1.59867
R177 a_92_987.n1 a_92_987.t2 11.6479
R178 a_92_987.t1 a_92_987.n1 11.5552
R179 a_92_987.n1 a_92_987.n0 7.5005
R180 a_92_987.n0 a_92_987.t0 3.03552
R181 a_92_987.n0 a_92_987.t3 3.03552
C0 B VDD 0.44289f
C1 A Y 0.18944f
C2 B Y 0.29242f
C3 A VDD 0.56688f
C4 Y VSS 0.47542f
C5 B VSS 0.91683f
C6 A VSS 1.01112f
C7 VDD VSS 3.23461f
C8 a_92_987.t2 VSS 0.16747f
C9 a_92_987.n1 VSS 0.4516f
C10 a_92_987.t1 VSS 0.16418f
C11 VSS.t3 VSS 0.14259f
C12 VSS.t1 VSS 0.14819f
C13 VDD.n0 VSS 0.11259f
C14 VDD.n16 VSS 0.10963f
C15 VDD.n30 VSS 0.18763f
C16 VDD.n33 VSS 0.18763f
C17 VDD.n34 VSS 0.10963f
C18 Y.t0 VSS 0.1509f
C19 Y.t3 VSS 0.1565f
.ends
