* NGSPICE file created from gf180mcu_ocd_sc_rt12t3v3__buf_2.ext - technology: gf180mcuD

.subckt gf180mcu_ocd_sc_rt12t3v3__buf_2 A Y VDD VSS
X0 VDD.t3 A.t1 a_193_203r# VDD.t2 pfet_03v3 ad=0.3341p pd=1.805u as=0.3341p ps=1.805u w=1.285u l=0.28u
X1 Y.t5 a_193_203r# VDD.t9 VDD.t8 pfet_03v3 ad=0.3341p pd=1.805u as=0.3341p ps=1.805u w=1.285u l=0.28u
X2 Y.t3 a_193_203r# VSS.t5 VSS.t4 nfet_03v3 ad=0.3087p pd=2.01u as=2.49132p ps=12.92u w=1.02u l=0.28u
X3 VDD.t11 a_193_203r# Y.t1 VDD.t10 pfet_03v3 ad=0.5654p pd=3.45u as=0.3341p ps=1.805u w=1.285u l=0.28u
X4 Y.t4 a_193_203r# VSS.t3 VSS.t2 nfet_03v3 ad=0.3087p pd=2.01u as=2.49132p ps=12.92u w=1.02u l=0.28u
X5 Y.t0 a_193_203r# VDD.t5 VDD.t4 pfet_03v3 ad=0.3341p pd=1.805u as=0.3341p ps=1.805u w=1.285u l=0.28u
X6 a_193_203r# A.t2 VDD.t1 VDD.t0 pfet_03v3 ad=0.3341p pd=1.805u as=0.5654p ps=3.45u w=1.285u l=0.28u
X7 VDD.t7 a_193_203r# Y.t2 VDD.t6 pfet_03v3 ad=0.3341p pd=1.805u as=0.3341p ps=1.805u w=1.285u l=0.28u
X8 a_193_203r# A.t0 VSS.t1 VSS.t0 nfet_03v3 ad=0.3087p pd=2.01u as=3.73697p ps=19.385u w=1.02u l=0.28u
R0 Y.n17 Y.t3 120.001
R1 Y.n13 Y.t4 120.001
R2 Y.n2 Y.n16 115.718
R3 Y.n6 Y.n12 115.718
R4 Y.n19 Y.n18 67.4693
R5 Y.n15 Y.n14 67.4693
R6 Y.n18 Y.n17 40.8056
R7 Y.n14 Y.n13 34.8011
R8 Y.n17 Y.n16 20.0898
R9 Y.n13 Y.n12 20.0898
R10 Y Y.n1 15.4398
R11 Y Y.n0 15.0005
R12 Y.n0 Y.n2 5.1751
R13 Y.n1 Y.n6 5.1751
R14 Y.n5 Y.n2 2.89242
R15 Y.n9 Y.n6 2.89242
R16 Y Y.n11 7.92328
R17 Y Y.n10 7.92328
R18 Y.n5 Y.n4 1.97827
R19 Y.n18 Y.n3 7.5005
R20 Y.n9 Y.n8 1.97827
R21 Y.n14 Y.n7 7.5005
R22 Y.n19 Y.n16 4.52242
R23 Y.n15 Y.n12 4.52242
R24 Y.n4 Y.t3 1.09191
R25 Y.n8 Y.t4 1.09191
R26 Y.n4 Y.n3 1.96464
R27 Y.n8 Y.n7 1.96464
R28 Y.n10 Y.t5 3.03552
R29 Y.n10 Y.t1 3.03552
R30 Y.n11 Y.t0 3.03552
R31 Y.n11 Y.t2 3.03552
R32 Y.n0 Y.t3 14.0052
R33 Y.n1 Y.t4 14.0052
R34 Y.n1 Y.n7 4.18614
R35 Y.n0 Y.n3 4.18614
R36 Y.n9 Y.n15 1.72383
R37 Y.n5 Y.n19 1.72383
R38 A.n0 A.t1 82.5005
R39 A.n0 A.t2 39.6434
R40 A A.n0 18.7416
R41 A A.t0 14.1269
R42 VDD.n41 VDD.n40 406.705
R43 VDD.n33 VDD.t10 164.505
R44 VDD.t10 VDD.n17 164.505
R45 VDD.n39 VDD.n17 164.505
R46 VDD.n43 VDD.n42 164.304
R47 VDD.n26 VDD.n25 164.304
R48 VDD.n30 VDD.n21 164.304
R49 VDD.n43 VDD.t0 140.832
R50 VDD.n31 VDD.t6 140.832
R51 VDD.n27 VDD.t2 117.359
R52 VDD.n27 VDD.t4 117.359
R53 VDD.n33 VDD.n32 108.691
R54 VDD.n32 VDD.n31 55.7462
R55 VDD.t2 VDD.n26 46.9443
R56 VDD.t4 VDD.n21 46.9443
R57 VDD.n32 VDD.t8 38.1423
R58 VDD.n25 VDD.t0 23.4724
R59 VDD.t6 VDD.n30 23.4724
R60 VDD.n37 VDD.n36 23.3338
R61 VDD.n45 VDD.n44 23.3338
R62 VDD.n44 VDD.n7 6.5635
R63 VDD.n24 VDD.n10 23.3338
R64 VDD.n28 VDD.n24 23.3338
R65 VDD.n5 VDD.n4 6.5635
R66 VDD.n29 VDD.n4 23.3338
R67 VDD.n6 VDD.n20 6.5635
R68 VDD.n34 VDD.n20 23.3338
R69 VDD.n34 VDD.n19 23.3338
R70 VDD.n8 VDD.n19 6.5635
R71 VDD.n38 VDD.n35 23.3338
R72 VDD.n13 VDD.n12 23.3338
R73 VDD.n2 VDD.n9 11.7458
R74 VDD.n3 VDD.n18 11.7458
R75 VDD VDD.n45 15.0005
R76 VDD.n44 VDD.n43 15.0005
R77 VDD.n7 VDD 4.21975
R78 VDD.n25 VDD.n10 15.0005
R79 VDD.n7 VDD.n10 6.5635
R80 VDD.n26 VDD.n24 15.0005
R81 VDD.n24 VDD 15.0005
R82 VDD.n28 VDD.n27 15.0005
R83 VDD.n5 VDD.n28 6.5635
R84 VDD.n4 VDD.n21 15.0005
R85 VDD VDD.n5 4.21975
R86 VDD.n30 VDD.n29 15.0005
R87 VDD.n29 VDD.n6 6.5635
R88 VDD.n31 VDD.n20 15.0005
R89 VDD.n6 VDD 4.21975
R90 VDD.n34 VDD.n33 15.0005
R91 VDD VDD.n34 15.0005
R92 VDD.t10 VDD.n19 15.0005
R93 VDD VDD.n8 4.21975
R94 VDD.n35 VDD.n17 15.0005
R95 VDD.n35 VDD.n8 6.5635
R96 VDD.n39 VDD.n38 15.0005
R97 VDD.n38 VDD.n3 5.18282
R98 VDD.n40 VDD.n39 15.0005
R99 VDD.n36 VDD.n1 15.0005
R100 VDD VDD.n37 15.0005
R101 VDD.n3 VDD 4.91009
R102 VDD.n2 VDD.n0 4.21975
R103 VDD.n0 VDD.n13 15.0005
R104 VDD.n42 VDD.n12 15.0005
R105 VDD.n42 VDD.n41 15.0005
R106 VDD.n16 VDD.n15 13.0955
R107 VDD VDD.t1 10.895
R108 VDD VDD.t11 10.8927
R109 VDD VDD.n22 7.85998
R110 VDD VDD.n23 7.85998
R111 VDD.n41 VDD.n14 6.64275
R112 VDD.n40 VDD.n15 6.64275
R113 VDD.n36 VDD.n16 6.5635
R114 VDD.n37 VDD.n18 6.5635
R115 VDD.n13 VDD.n11 6.5635
R116 VDD.n2 VDD.n11 13.1265
R117 VDD.n14 VDD.n12 6.53249
R118 VDD.n45 VDD.n9 5.18282
R119 VDD.n42 VDD.n9 4.91009
R120 VDD.n1 VDD.n15 4.52391
R121 VDD.n14 VDD.n0 4.52391
R122 VDD.n39 VDD.n16 4.21975
R123 VDD.n39 VDD.n18 4.21975
R124 VDD.n42 VDD.n11 4.21975
R125 VDD.n22 VDD.t7 3.03552
R126 VDD.n22 VDD.t9 3.03552
R127 VDD.n23 VDD.t3 3.03552
R128 VDD.n23 VDD.t5 3.03552
R129 VDD VDD.n0 1.30397
R130 VDD VDD.n1 1.01277
R131 VSS.n43 VSS.n42 514.125
R132 VSS.n26 VSS.n25 514.125
R133 VSS.n26 VSS.n24 514.125
R134 VSS.n30 VSS.n29 514.125
R135 VSS.n30 VSS.n21 514.125
R136 VSS.n34 VSS.n33 514.125
R137 VSS.n35 VSS.n34 514.125
R138 VSS.n35 VSS.n18 514.125
R139 VSS.n24 VSS.t2 472.812
R140 VSS.n40 VSS.n39 434.205
R141 VSS.n21 VSS.t4 403.955
R142 VSS.n43 VSS.t0 316.738
R143 VSS.n25 VSS.t0 197.387
R144 VSS.n33 VSS.t4 110.169
R145 VSS.n29 VSS.t2 41.3141
R146 VSS.n44 VSS.n17 23.3338
R147 VSS.n36 VSS.n12 23.0142
R148 VSS.n27 VSS.n22 22.3675
R149 VSS.n15 VSS.n22 6.32546
R150 VSS.n36 VSS.n14 6.29304
R151 VSS.n13 VSS.n16 6.23424
R152 VSS.n31 VSS.n16 21.306
R153 VSS.n44 VSS.n5 20.9317
R154 VSS.n11 VSS.n17 15.8338
R155 VSS.n10 VSS.n12 5.13799
R156 VSS VSS.n40 15.2537
R157 VSS.n39 VSS 15.2537
R158 VSS.n44 VSS.n43 15.0005
R159 VSS VSS.n44 15.0005
R160 VSS.n42 VSS.n17 15.0005
R161 VSS.n17 VSS 15.0005
R162 VSS.n27 VSS.n26 15.0005
R163 VSS VSS.n4 3.01553
R164 VSS.n25 VSS.n5 15.0005
R165 VSS.n5 VSS 15.0005
R166 VSS.n24 VSS.n22 15.0005
R167 VSS VSS.n15 4.33877
R168 VSS.n31 VSS.n30 15.0005
R169 VSS VSS.n2 3.6097
R170 VSS.n29 VSS.n28 15.0005
R171 VSS.n28 VSS.n15 6.32546
R172 VSS.n21 VSS.n16 15.0005
R173 VSS VSS.n13 4.38438
R174 VSS.n34 VSS.n0 15.0005
R175 VSS.n14 VSS.n0 6.29304
R176 VSS.n33 VSS.n32 15.0005
R177 VSS.n32 VSS.n13 6.23424
R178 VSS.n12 VSS.n18 15.0005
R179 VSS VSS.n10 4.93251
R180 VSS.n36 VSS.n35 15.0005
R181 VSS VSS.n14 4.35498
R182 VSS.n9 VSS 4.21975
R183 VSS.n37 VSS.n9 13.1265
R184 VSS VSS.n11 15.0005
R185 VSS VSS.n8 4.21975
R186 VSS.n27 VSS.n4 5.95742
R187 VSS.n28 VSS.n3 11.5668
R188 VSS.n1 VSS.n0 11.386
R189 VSS.n1 VSS.t5 10.5005
R190 VSS.n3 VSS.t3 10.5005
R191 VSS.n6 VSS.t1 10.5005
R192 VSS.n32 VSS.n1 8.85592
R193 VSS.n31 VSS.n2 4.17491
R194 VSS.n6 VSS.n4 2.97921
R195 VSS.n3 VSS.n2 2.08796
R196 VSS VSS.n1 7.5005
R197 VSS.n6 VSS.n23 6.6005
R198 VSS.n40 VSS.n7 6.5635
R199 VSS.n39 VSS.n38 6.5635
R200 VSS.n41 VSS.n11 6.5635
R201 VSS.n41 VSS.n8 13.1265
R202 VSS.n8 VSS.n7 13.1265
R203 VSS.n37 VSS.n10 11.701
R204 VSS.n38 VSS.n9 13.1265
R205 VSS.n3 VSS.n20 7.0505
R206 VSS.n1 VSS.n19 7.0505
R207 VSS.n6 VSS.n5 5.87219
R208 VSS.n38 VSS.n18 4.21975
R209 VSS.n37 VSS.n18 4.21975
R210 VSS.n42 VSS.n41 4.21975
R211 VSS.n42 VSS.n7 4.21975
C0 Y a_193_203r# 0.47941f
C1 VDD Y 0.4559f
C2 VDD a_193_203r# 0.95318f
C3 A a_193_203r# 0.29815f
C4 VDD A 0.44412f
C5 Y VSS 0.59301f
C6 A VSS 0.91682f
C7 VDD VSS 4.13773f
C8 a_193_203r# VSS 0.12117f
C9 VSS.t1 VSS 0.12117f
C10 VDD.t9 VSS 0.46633f
C11 VDD.n39 VSS 0.15094f
C12 VDD.n42 VSS 0.15112f
C13 Y.t5 VSS 0.48204f
.ends
