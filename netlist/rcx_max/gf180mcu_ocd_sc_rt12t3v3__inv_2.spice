* NGSPICE file created from gf180mcu_ocd_sc_rt12t3v3__inv_2.ext - technology: gf180mcuD

.subckt gf180mcu_ocd_sc_rt12t3v3__inv_2 A Y VDD VSS
X0 Y.t3 A.t4 VDD.t1 VDD.t0 pfet_03v3 ad=0.4459p pd=2.235u as=0.7546p ps=4.31u w=1.715u l=0.28u
X1 Y.t0 A.t0 VSS.t3 VSS.t2 nfet_03v3 ad=0.3087p pd=2.01u as=2.75995p ps=14.36u w=1.02u l=0.28u
X2 Y.t4 A.t1 VSS.t1 VSS.t0 nfet_03v3 ad=0.3087p pd=2.01u as=2.75995p ps=14.36u w=1.02u l=0.28u
X3 VDD.t3 A.t3 Y.t2 VDD.t2 pfet_03v3 ad=0.4459p pd=2.235u as=0.4459p ps=2.235u w=1.715u l=0.28u
X4 Y.t1 A.t2 VDD.t5 VDD.t4 pfet_03v3 ad=0.7546p pd=4.31u as=0.4459p ps=2.235u w=1.715u l=0.28u
R0 Y.n15 Y.t0 120.001
R1 Y.n11 Y.t4 120.001
R2 Y.n2 Y.n14 115.718
R3 Y.n6 Y.n10 115.718
R4 Y.n17 Y.n16 67.4693
R5 Y.n13 Y.n12 67.4693
R6 Y.n16 Y.n15 40.8056
R7 Y.n12 Y.n11 34.8011
R8 Y.n15 Y.n14 20.0898
R9 Y.n11 Y.n10 20.0898
R10 Y Y.n1 15.7285
R11 Y Y.n0 15.0005
R12 Y.n0 Y.n2 5.1751
R13 Y.n1 Y.n6 5.1751
R14 Y.n5 Y.n2 2.89242
R15 Y.n9 Y.n6 2.89242
R16 Y.n19 Y.t1 7.77647
R17 Y.n5 Y.n4 1.97827
R18 Y.n16 Y.n3 7.5005
R19 Y.n9 Y.n8 1.97827
R20 Y.n12 Y.n7 7.5005
R21 Y.n19 Y.n18 6.22137
R22 Y.n17 Y.n14 4.52242
R23 Y.n13 Y.n10 4.52242
R24 Y.n4 Y.t0 1.09191
R25 Y.n8 Y.t4 1.09191
R26 Y.n4 Y.n3 1.96464
R27 Y.n8 Y.n7 1.96464
R28 Y.n18 Y.t3 2.27455
R29 Y.n18 Y.t2 2.27455
R30 Y.n0 Y.t0 14.0052
R31 Y.n1 Y.t4 14.0052
R32 Y.n1 Y.n7 4.18614
R33 Y.n0 Y.n3 4.18614
R34 Y.n9 Y.n13 1.72383
R35 Y.n5 Y.n17 1.72383
R36 Y Y.n19 1.41589
R37 A.n4 A.t2 94.0184
R38 A.n10 A.n9 65.353
R39 A.n5 A.t4 51.1612
R40 A.n4 A.t3 51.1612
R41 A.n5 A.n4 42.8576
R42 A.n0 A.n8 29.6596
R43 A.n8 A.n7 27.6834
R44 A.n7 A.t0 8.32006
R45 A.n7 A.n1 29.8005
R46 A A.n5 18.5471
R47 A.n1 A.n2 20.7995
R48 A.n10 A.t1 12.0226
R49 A.n11 A.n2 10.7301
R50 A.n9 A.n6 10.6228
R51 A.n9 A.n3 10.2242
R52 A.t0 A.n6 63.9155
R53 A.n3 A.t1 9.44551
R54 A.n0 A.n3 9.87028
R55 A.n0 A.n1 1.17324
R56 A A.n11 5.48207
R57 A.t1 A.n2 3.87592
R58 A.n11 A.n10 2.25856
R59 A.n8 A.n6 2.2522
R60 VDD.n30 VDD.n29 253.977
R61 VDD.n32 VDD.n31 164.505
R62 VDD.n22 VDD.n21 164.505
R63 VDD.n20 VDD.n16 164.505
R64 VDD.n28 VDD.n16 164.505
R65 VDD.n32 VDD.t0 141.005
R66 VDD.n23 VDD.t2 117.504
R67 VDD.n23 VDD.t4 117.504
R68 VDD.t2 VDD.n22 47.0017
R69 VDD.t4 VDD.n20 47.0017
R70 VDD.n21 VDD.t0 23.5011
R71 VDD.n2 VDD.n15 13.1265
R72 VDD.n34 VDD.n33 23.3338
R73 VDD.n33 VDD.n6 6.5635
R74 VDD.n19 VDD.n8 23.3338
R75 VDD.n24 VDD.n19 23.3338
R76 VDD.n4 VDD.n3 6.5635
R77 VDD.n25 VDD.n3 23.3338
R78 VDD.n27 VDD.n5 6.5635
R79 VDD.n13 VDD.n10 23.3338
R80 VDD.n12 VDD.n11 23.3338
R81 VDD.n27 VDD.n26 15.8338
R82 VDD VDD.n34 15.0005
R83 VDD.n33 VDD.n32 15.0005
R84 VDD.n6 VDD 4.21975
R85 VDD.n21 VDD.n8 15.0005
R86 VDD.n6 VDD.n8 6.5635
R87 VDD.n22 VDD.n19 15.0005
R88 VDD.n19 VDD.n1 15.0005
R89 VDD.n24 VDD.n23 15.0005
R90 VDD.n4 VDD.n24 6.5635
R91 VDD.n20 VDD.n3 15.0005
R92 VDD.n1 VDD.n4 4.21975
R93 VDD.n25 VDD.n16 15.0005
R94 VDD.n25 VDD.n5 6.5635
R95 VDD.n28 VDD.n27 15.0005
R96 VDD.n5 VDD.n1 4.21975
R97 VDD.n29 VDD.n28 15.0005
R98 VDD.n2 VDD.n1 4.21975
R99 VDD.n26 VDD.n1 15.0005
R100 VDD.n11 VDD 15.0005
R101 VDD VDD.n12 15.0005
R102 VDD VDD.n13 15.0005
R103 VDD.n31 VDD.n10 15.0005
R104 VDD.n31 VDD.n30 15.0005
R105 VDD.n15 VDD.n0 13.0955
R106 VDD VDD.t1 7.73125
R107 VDD.n30 VDD.n14 6.64275
R108 VDD.n29 VDD.n0 6.64275
R109 VDD.n26 VDD.n17 6.5635
R110 VDD.n2 VDD.n17 13.1265
R111 VDD.n13 VDD.n9 6.5635
R112 VDD.n12 VDD.n9 6.5635
R113 VDD.n14 VDD.n10 6.53249
R114 VDD.n1 VDD.n18 5.46624
R115 VDD.n11 VDD.n7 5.18282
R116 VDD.n34 VDD.n7 5.18282
R117 VDD.n31 VDD.n7 4.91009
R118 VDD.n1 VDD.n0 4.52391
R119 VDD.n14 VDD 4.52391
R120 VDD.n28 VDD.n15 4.21975
R121 VDD.n28 VDD.n17 4.21975
R122 VDD.n31 VDD.n9 4.21975
R123 VDD.n18 VDD.t3 2.27455
R124 VDD.n18 VDD.t5 2.27455
R125 VDD.n1 VDD 1.92797
R126 VSS.n32 VSS.n31 513.399
R127 VSS.n17 VSS.n16 513.399
R128 VSS.n21 VSS.n17 513.399
R129 VSS.n23 VSS.n22 513.399
R130 VSS.n23 VSS.n14 513.399
R131 VSS.n22 VSS.t2 352.962
R132 VSS.n16 VSS.t0 288.788
R133 VSS.n29 VSS.n28 281.478
R134 VSS.n32 VSS.t0 224.613
R135 VSS.t2 VSS.n21 160.438
R136 VSS.n33 VSS.n13 23.3338
R137 VSS.n24 VSS.n10 6.55913
R138 VSS.n20 VSS.n11 6.45735
R139 VSS.n33 VSS.n12 20.3795
R140 VSS.n24 VSS.n0 20.2415
R141 VSS.n20 VSS.n2 19.5186
R142 VSS.n4 VSS.n3 18.4342
R143 VSS.n6 VSS.n13 15.8338
R144 VSS.n25 VSS.n15 15.8338
R145 VSS VSS.n29 15.2537
R146 VSS.n28 VSS.n1 15.2537
R147 VSS.n33 VSS.n32 15.0005
R148 VSS VSS.n33 15.0005
R149 VSS.n31 VSS.n13 15.0005
R150 VSS.n13 VSS 15.0005
R151 VSS.n3 VSS.n17 15.0005
R152 VSS.n11 VSS.n3 6.45735
R153 VSS.n16 VSS.n12 15.0005
R154 VSS.n5 VSS 4.54513
R155 VSS.n22 VSS.n0 15.0005
R156 VSS VSS.n0 4.75327
R157 VSS.n21 VSS.n20 15.0005
R158 VSS.n11 VSS 4.27283
R159 VSS.n15 VSS.n14 15.0005
R160 VSS.n10 VSS.n15 6.55913
R161 VSS.n24 VSS.n23 15.0005
R162 VSS.n1 VSS.n10 4.22194
R163 VSS.n9 VSS.n1 4.21975
R164 VSS.n26 VSS.n9 13.1265
R165 VSS.n25 VSS.n1 15.0005
R166 VSS VSS.n6 15.0005
R167 VSS VSS.n8 4.21975
R168 VSS.n2 VSS.t3 10.5005
R169 VSS.n4 VSS.t1 10.5005
R170 VSS.n5 VSS.n4 0.684809
R171 VSS.n2 VSS.n18 6.6005
R172 VSS.n4 VSS.n19 6.6005
R173 VSS.n29 VSS.n7 6.5635
R174 VSS.n28 VSS.n27 6.5635
R175 VSS.n30 VSS.n6 6.5635
R176 VSS.n30 VSS.n8 13.1265
R177 VSS.n8 VSS.n7 13.1265
R178 VSS.n26 VSS.n25 6.5635
R179 VSS.n27 VSS.n9 13.1265
R180 VSS.n27 VSS.n14 4.21975
R181 VSS.n26 VSS.n14 4.21975
R182 VSS.n31 VSS.n30 4.21975
R183 VSS.n31 VSS.n7 4.21975
R184 VSS.n5 VSS.n12 1.36862
R185 VSS VSS.n1 1.29817
R186 VSS.n0 VSS.n2 1.11628
R187 VSS.n1 VSS 1.0824
C0 VDD A 0.61279f
C1 VDD Y 0.52692f
C2 A Y 0.39484f
C3 Y VSS 0.41573f
C4 A VSS 1.13171f
C5 VDD VSS 2.85291f
C6 VDD.n28 VSS 0.1312f
C7 VDD.n31 VSS 0.1312f
C8 A.n10 VSS 0.12507f
C9 Y.t1 VSS 0.11793f
C10 Y.n19 VSS 0.22816f
.ends
