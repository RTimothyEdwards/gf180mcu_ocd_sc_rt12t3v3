* NGSPICE file created from gf180mcu_ocd_sc_rt12t3v3__or2_1.ext - technology: gf180mcuD

.subckt gf180mcu_ocd_sc_rt12t3v3__or2_1 A B Y VDD VSS
X0 a_92_987.t3 B.t1 VDD.t3 VDD.t2 pfet_03v3 ad=0.3341p pd=1.805u as=0.3341p ps=1.805u w=1.285u l=0.28u
X1 a_193_203r# A.t0 VSS.t1 VSS.t0 nfet_03v3 ad=0.3087p pd=2.01u as=2.59775p ps=13.675u w=1.02u l=0.28u
X2 VDD.t9 a_193_203r# Y.t2 VDD.t8 pfet_03v3 ad=0.5654p pd=3.45u as=0.3341p ps=1.805u w=1.285u l=0.28u
X3 a_193_203r# A.t2 a_92_987.t0 VDD.t0 pfet_03v3 ad=0.3341p pd=1.805u as=0.3341p ps=1.805u w=1.285u l=0.28u
X4 VDD.t5 B.t2 a_92_987.t2 VDD.t4 pfet_03v3 ad=0.3341p pd=1.805u as=0.5654p ps=3.45u w=1.285u l=0.28u
X5 a_92_987.t1 A.t1 a_193_203r# VDD.t1 pfet_03v3 ad=0.5654p pd=3.45u as=0.3341p ps=1.805u w=1.285u l=0.28u
X6 Y.t1 a_193_203r# VDD.t7 VDD.t6 pfet_03v3 ad=0.3341p pd=1.805u as=0.5654p ps=3.45u w=1.285u l=0.28u
X7 Y.t0 a_193_203r# VSS.t5 VSS.t4 nfet_03v3 ad=0.3087p pd=2.01u as=2.59775p ps=13.675u w=1.02u l=0.28u
X8 a_193_203r# B.t0 VSS.t3 VSS.t2 nfet_03v3 ad=0.3087p pd=2.01u as=2.59775p ps=13.675u w=1.02u l=0.28u
R0 Y.n6 Y.t0 120.001
R1 Y.n1 Y.n5 115.718
R2 Y.n8 Y.n7 67.4693
R3 Y.n7 Y.n6 34.8011
R4 Y.n6 Y.n5 20.0898
R5 Y Y.n0 15.0525
R6 Y.n0 Y.n1 5.1751
R7 Y.n4 Y.n1 2.89242
R8 Y Y.n9 7.94732
R9 Y.n4 Y.n3 1.97827
R10 Y.n7 Y.n2 7.5005
R11 Y.n8 Y.n5 4.52242
R12 Y.n3 Y.t0 1.09191
R13 Y.n3 Y.n2 1.96464
R14 Y.n9 Y.t1 3.03552
R15 Y.n9 Y.t2 3.03552
R16 Y.n0 Y.t0 14.0052
R17 Y.n0 Y.n2 4.18614
R18 Y.n4 Y.n8 1.72383
R19 A.n4 A.n3 307.5
R20 A.t0 A.n2 217.5
R21 A.n10 A.t1 82.5005
R22 A.n8 A.n7 68.002
R23 A.n10 A.t2 39.6434
R24 A.n7 A.n2 30.0005
R25 A.n3 A.n1 20.7085
R26 A A.n10 18.5091
R27 A.n8 A.n1 12.0226
R28 A.n7 A.n6 11.5184
R29 A.n9 A.n0 9.7624
R30 A A.n9 8.52241
R31 A.n5 A.n4 7.5005
R32 A.n6 A.n3 7.5005
R33 A.n5 A.t0 7.23264
R34 A.n4 A.n2 5.49918
R35 A.n6 A.n5 4.01836
R36 A.n1 A.n0 3.87592
R37 A.n9 A.n8 3.22631
R38 A.n4 A.n0 1.73654
R39 B.n0 B.t1 82.5005
R40 B B.n0 43.1394
R41 B.n0 B.t2 39.6434
R42 B B.t0 17.4337
R43 VDD.n42 VDD.n41 444.887
R44 VDD.n44 VDD.n43 164.505
R45 VDD.n29 VDD.n26 164.505
R46 VDD.n31 VDD.n25 164.505
R47 VDD.n35 VDD.n34 164.505
R48 VDD.n36 VDD.n23 164.505
R49 VDD.n40 VDD.n19 164.505
R50 VDD.n44 VDD.t4 141.005
R51 VDD.n34 VDD.t1 141.005
R52 VDD.t8 VDD.n19 141.005
R53 VDD.n30 VDD.t2 117.504
R54 VDD.t0 VDD.n30 117.504
R55 VDD.t6 VDD.n35 117.504
R56 VDD.t2 VDD.n29 47.0017
R57 VDD.n31 VDD.t0 47.0017
R58 VDD.n36 VDD.t6 47.0017
R59 VDD.n26 VDD.t4 23.5011
R60 VDD.n25 VDD.t1 23.5011
R61 VDD.n23 VDD.t8 23.5011
R62 VDD.n2 VDD.n18 13.1265
R63 VDD.n46 VDD.n45 23.3338
R64 VDD.n45 VDD.n8 23.3338
R65 VDD.n9 VDD.n8 6.5635
R66 VDD.n28 VDD.n24 23.3338
R67 VDD.n32 VDD.n24 23.3338
R68 VDD.n5 VDD.n4 6.5635
R69 VDD.n33 VDD.n4 23.3338
R70 VDD.n6 VDD.n22 6.5635
R71 VDD.n37 VDD.n22 23.3338
R72 VDD.n37 VDD.n21 23.3338
R73 VDD.n7 VDD.n21 6.5635
R74 VDD.n39 VDD.n38 23.3338
R75 VDD.n15 VDD.n12 23.3338
R76 VDD.n14 VDD.n13 23.3338
R77 VDD.n3 VDD.n20 11.7458
R78 VDD VDD.n46 15.0005
R79 VDD.n45 VDD.n44 15.0005
R80 VDD.n45 VDD 15.0005
R81 VDD.n26 VDD.n8 15.0005
R82 VDD VDD.n9 4.21975
R83 VDD.n29 VDD.n28 15.0005
R84 VDD.n28 VDD.n9 6.5635
R85 VDD.n30 VDD.n24 15.0005
R86 VDD.n24 VDD 15.0005
R87 VDD.n32 VDD.n31 15.0005
R88 VDD.n5 VDD.n32 6.5635
R89 VDD.n25 VDD.n4 15.0005
R90 VDD VDD.n5 4.21975
R91 VDD.n34 VDD.n33 15.0005
R92 VDD.n33 VDD.n6 6.5635
R93 VDD.n35 VDD.n22 15.0005
R94 VDD.n6 VDD 4.21975
R95 VDD.n37 VDD.n36 15.0005
R96 VDD VDD.n37 15.0005
R97 VDD.n23 VDD.n21 15.0005
R98 VDD VDD.n7 4.21975
R99 VDD.n38 VDD.n19 15.0005
R100 VDD.n38 VDD.n7 6.5635
R101 VDD.n40 VDD.n39 15.0005
R102 VDD.n39 VDD.n3 5.18282
R103 VDD.n41 VDD.n40 15.0005
R104 VDD.n2 VDD.n1 4.21975
R105 VDD.n3 VDD.n1 4.91009
R106 VDD.n13 VDD 15.0005
R107 VDD VDD.n14 15.0005
R108 VDD.n16 VDD.n15 15.0005
R109 VDD.n43 VDD.n12 15.0005
R110 VDD.n43 VDD.n42 15.0005
R111 VDD.n18 VDD.n0 13.0955
R112 VDD VDD.t7 10.895
R113 VDD VDD.t9 10.8927
R114 VDD VDD.n27 7.83511
R115 VDD.n42 VDD.n17 6.64275
R116 VDD.n41 VDD.n0 6.64275
R117 VDD.n2 VDD.n20 13.1265
R118 VDD.n15 VDD.n11 6.5635
R119 VDD.n14 VDD.n11 6.5635
R120 VDD.n17 VDD.n12 6.53249
R121 VDD.n13 VDD.n10 5.18282
R122 VDD.n46 VDD.n10 5.18282
R123 VDD.n43 VDD.n10 4.91009
R124 VDD.n1 VDD.n0 4.52391
R125 VDD.n17 VDD.n16 4.52391
R126 VDD.n40 VDD.n18 4.21975
R127 VDD.n40 VDD.n20 4.21975
R128 VDD.n43 VDD.n11 4.21975
R129 VDD.n27 VDD.t5 3.03552
R130 VDD.n27 VDD.t3 3.03552
R131 VDD VDD.n1 1.40103
R132 VDD.n16 VDD 1.01277
R133 VSS.n45 VSS.n44 513.399
R134 VSS.n27 VSS.n26 513.399
R135 VSS.n28 VSS.n27 513.399
R136 VSS.n28 VSS.n25 513.399
R137 VSS.n31 VSS.n30 513.399
R138 VSS.n31 VSS.n22 513.399
R139 VSS.n35 VSS.n34 513.399
R140 VSS.n36 VSS.n35 513.399
R141 VSS.n36 VSS.n18 513.399
R142 VSS.n42 VSS.n41 472.387
R143 VSS.n22 VSS.t4 343.795
R144 VSS.n30 VSS.t0 325.459
R145 VSS.n45 VSS.t2 316.291
R146 VSS.n26 VSS.t2 197.109
R147 VSS.n25 VSS.t0 187.941
R148 VSS.n34 VSS.t4 169.606
R149 VSS.n37 VSS.n12 6.5635
R150 VSS.n46 VSS.n17 23.3338
R151 VSS.n29 VSS.n16 23.251
R152 VSS.n32 VSS.n14 23.1406
R153 VSS.n29 VSS.n24 22.3675
R154 VSS.n37 VSS.n15 22.2018
R155 VSS.n33 VSS.n13 6.1942
R156 VSS.n46 VSS.n5 20.9317
R157 VSS.n1 VSS.n16 7.67488
R158 VSS.n32 VSS.n0 19.88
R159 VSS.n11 VSS.n17 15.8338
R160 VSS.n38 VSS.n19 15.8338
R161 VSS VSS.n42 15.2537
R162 VSS.n41 VSS.n2 15.2537
R163 VSS.n46 VSS.n45 15.0005
R164 VSS VSS.n46 15.0005
R165 VSS.n44 VSS.n17 15.0005
R166 VSS.n17 VSS 15.0005
R167 VSS.n27 VSS.n24 15.0005
R168 VSS.n7 VSS 3.01553
R169 VSS.n26 VSS.n5 15.0005
R170 VSS.n5 VSS 15.0005
R171 VSS.n25 VSS.n16 15.0005
R172 VSS VSS.n1 1.78457
R173 VSS.n29 VSS.n28 15.0005
R174 VSS VSS.n29 15.0005
R175 VSS.n30 VSS.n0 15.0005
R176 VSS.n22 VSS.n14 15.0005
R177 VSS.n13 VSS.n14 6.1942
R178 VSS.n32 VSS.n31 15.0005
R179 VSS VSS.n32 15.0005
R180 VSS.n35 VSS.n15 15.0005
R181 VSS VSS.n4 3.10574
R182 VSS.n34 VSS.n33 15.0005
R183 VSS.n13 VSS 4.4044
R184 VSS.n19 VSS.n18 15.0005
R185 VSS.n12 VSS.n19 6.5635
R186 VSS.n37 VSS.n36 15.0005
R187 VSS VSS.n12 4.21975
R188 VSS.n10 VSS.n2 4.21975
R189 VSS.n39 VSS.n10 13.1265
R190 VSS.n38 VSS 15.0005
R191 VSS VSS.n11 15.0005
R192 VSS VSS.n9 4.21975
R193 VSS.n24 VSS.n7 5.95742
R194 VSS.n4 VSS.n15 5.68679
R195 VSS.n3 VSS.t5 10.5005
R196 VSS.n0 VSS.t1 10.5005
R197 VSS.n6 VSS.t3 10.5005
R198 VSS.n7 VSS.n6 2.97921
R199 VSS.n1 VSS.n0 2.73081
R200 VSS.n4 VSS.n3 2.84389
R201 VSS.n3 VSS.n20 6.6005
R202 VSS.n0 VSS.n21 6.6005
R203 VSS.n6 VSS.n23 6.6005
R204 VSS.n42 VSS.n8 6.5635
R205 VSS.n41 VSS.n40 6.5635
R206 VSS.n43 VSS.n11 6.5635
R207 VSS.n43 VSS.n9 13.1265
R208 VSS.n9 VSS.n8 13.1265
R209 VSS.n39 VSS.n38 6.5635
R210 VSS.n40 VSS.n10 13.1265
R211 VSS.n33 VSS.n3 6.95652
R212 VSS.n6 VSS.n5 5.87219
R213 VSS.n40 VSS.n18 4.21975
R214 VSS.n39 VSS.n18 4.21975
R215 VSS.n44 VSS.n43 4.21975
R216 VSS.n44 VSS.n8 4.21975
R217 VSS VSS.n2 1.41854
R218 a_92_987.n1 a_92_987.t2 11.6479
R219 a_92_987.t1 a_92_987.n1 11.5552
R220 a_92_987.n1 a_92_987.n0 7.5005
R221 a_92_987.n0 a_92_987.t0 3.03552
R222 a_92_987.n0 a_92_987.t3 3.03552
C0 A a_193_203r# 0.34692f
C1 VDD Y 0.30681f
C2 Y a_193_203r# 0.31824f
C3 A VDD 0.39345f
C4 B VDD 0.5691f
C5 VDD a_193_203r# 0.49544f
C6 Y VSS 0.61678f
C7 A VSS 0.71699f
C8 B VSS 0.97238f
C9 VDD VSS 4.51487f
C10 a_193_203r# VSS 0.13803f
C11 a_92_987.t2 VSS 0.16433f
C12 a_92_987.n1 VSS 0.44949f
C13 a_92_987.t1 VSS 0.17562f
C14 VSS.t3 VSS 0.13803f
C15 VDD.n19 VSS 0.10777f
C16 VDD.t9 VSS 0.33939f
C17 VDD.n34 VSS 0.10777f
C18 VDD.n40 VSS 0.18446f
C19 VDD.n43 VSS 0.18446f
C20 VDD.n44 VSS 0.10777f
C21 A.n7 VSS 0.11395f
C22 A.n8 VSS 0.16711f
C23 Y.t2 VSS 0.34252f
.ends
