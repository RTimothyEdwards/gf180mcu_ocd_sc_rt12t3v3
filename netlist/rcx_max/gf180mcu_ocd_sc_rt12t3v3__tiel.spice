* NGSPICE file created from gf180mcu_ocd_sc_rt12t3v3__tiel.ext - technology: gf180mcuD

.subckt gf180mcu_ocd_sc_rt12t3v3__tiel Y VDD VSS
X0 VDD.t3 a_93_147.t2 a_93_147.t3 VDD.t2 pfet_03v3 ad=2.7424p pd=12.83u as=0.3341p ps=1.805u w=1.285u l=0.28u
X1 a_93_147.t1 a_93_147.t0 VDD.t1 VDD.t0 pfet_03v3 ad=0.3341p pd=1.805u as=2.7424p ps=12.83u w=1.285u l=0.28u
X2 Y.t0 a_93_147.t4 VSS.t1 VSS.t0 nfet_03v3 ad=0.3087p pd=2.01u as=4.22095p ps=23.13u w=1.02u l=0.28u
R0 Y.n6 Y.t0 120.001
R1 Y.n1 Y.n5 115.718
R2 Y.n8 Y.n7 67.4693
R3 Y.n7 Y.n6 34.8011
R4 Y.n6 Y.n5 20.0898
R5 Y Y.n0 15.2304
R6 Y.n0 Y.n1 5.1751
R7 Y.n4 Y.n1 2.89242
R8 Y.n4 Y.n3 1.97827
R9 Y.n7 Y.n2 7.5005
R10 Y.n8 Y.n5 4.52242
R11 Y.n3 Y.t0 1.09191
R12 Y.n3 Y.n2 1.96464
R13 Y.n0 Y.t0 14.0052
R14 Y.n0 Y.n2 4.18614
R15 Y.n4 Y.n8 1.72383
R16 VDD.n18 VDD.n14 177.614
R17 VDD.n28 VDD.n13 164.505
R18 VDD.n23 VDD.n22 164.505
R19 VDD.n21 VDD.n0 164.505
R20 VDD.t0 VDD.n13 141.005
R21 VDD.t2 VDD.n21 117.504
R22 VDD.n22 VDD.t2 47.0017
R23 VDD.n23 VDD.t0 23.5011
R24 VDD.n29 VDD.n12 23.3338
R25 VDD.n24 VDD.n10 6.5635
R26 VDD.n24 VDD.n16 23.3338
R27 VDD.n20 VDD.n16 23.3338
R28 VDD.n9 VDD.n19 11.5508
R29 VDD.n7 VDD.n17 12.8718
R30 VDD VDD.n18 15.2537
R31 VDD.n29 VDD.n28 15.0005
R32 VDD VDD.n29 15.0005
R33 VDD.n13 VDD.n12 15.0005
R34 VDD.n12 VDD.n10 6.5635
R35 VDD.n24 VDD.n23 15.0005
R36 VDD VDD.n10 4.21975
R37 VDD.n22 VDD.n16 15.0005
R38 VDD.n16 VDD 15.0005
R39 VDD.n21 VDD.n20 15.0005
R40 VDD.n20 VDD.n9 6.5635
R41 VDD VDD.n9 4.21975
R42 VDD.n11 VDD 15.0005
R43 VDD.n5 VDD.n6 4.42249
R44 VDD.n8 VDD.n6 5.29026
R45 VDD.n28 VDD.n14 15.0005
R46 VDD VDD.n7 4.34708
R47 VDD.n1 VDD.n0 5.07653
R48 VDD.n4 VDD.n1 4.84994
R49 VDD.n4 VDD.n2 5.001
R50 VDD VDD.n2 5.001
R51 VDD.n19 VDD.n2 9.98825
R52 VDD.n29 VDD.n11 14.7401
R53 VDD.n1 VDD.n7 11.1583
R54 VDD.n26 VDD.n15 12.7814
R55 VDD.n15 VDD.n6 10.6714
R56 VDD.n25 VDD 7.85998
R57 VDD VDD.n3 7.85772
R58 VDD.n26 VDD.n14 6.64275
R59 VDD.n18 VDD.n17 6.5635
R60 VDD.n28 VDD.n27 5.21839
R61 VDD.n19 VDD.n0 5.00762
R62 VDD.n27 VDD.n11 4.56622
R63 VDD.n27 VDD.n5 4.56622
R64 VDD.n8 VDD.n26 4.52391
R65 VDD.n28 VDD.n15 4.37679
R66 VDD.n17 VDD.n0 4.21975
R67 VDD.n25 VDD.t1 3.03552
R68 VDD.n3 VDD.t3 3.03552
R69 VDD.n4 VDD.n3 2.77131
R70 VDD.n5 VDD.n25 2.6876
R71 VDD.n8 VDD 1.98705
R72 VSS.n15 VSS.n12 453.695
R73 VSS.n23 VSS.n8 452.736
R74 VSS.n18 VSS.n12 452.736
R75 VSS.t0 VSS.n8 254.665
R76 VSS.n18 VSS.t0 198.072
R77 VSS.n17 VSS.n5 23.3338
R78 VSS.n17 VSS.n13 23.3338
R79 VSS.n4 VSS.n19 6.5635
R80 VSS.n19 VSS.n11 23.3338
R81 VSS.n22 VSS.n6 22.3675
R82 VSS.n25 VSS.n1 20.9317
R83 VSS.n16 VSS.n15 19.7293
R84 VSS.n15 VSS.n14 19.7293
R85 VSS.n5 VSS.n7 15.8338
R86 VSS.n21 VSS.n20 15.8338
R87 VSS VSS.n25 15.0005
R88 VSS.n7 VSS 15.0005
R89 VSS.n23 VSS.n22 15.0005
R90 VSS.n3 VSS 3.01553
R91 VSS.n23 VSS.n1 15.0005
R92 VSS.n1 VSS 15.0005
R93 VSS VSS.n21 15.0005
R94 VSS VSS.n6 15.0005
R95 VSS.n12 VSS.n11 15.0005
R96 VSS.n19 VSS.n18 15.0005
R97 VSS.n4 VSS.n0 4.21975
R98 VSS.n20 VSS.n8 15.0005
R99 VSS.n20 VSS.n4 6.5635
R100 VSS.n5 VSS.n8 15.0005
R101 VSS VSS.n5 15.0005
R102 VSS.n18 VSS.n17 15.0005
R103 VSS.n17 VSS 15.0005
R104 VSS.n13 VSS.n12 15.0005
R105 VSS.n22 VSS.n3 5.95742
R106 VSS.n2 VSS.t1 10.5005
R107 VSS.n3 VSS.n2 2.97921
R108 VSS.n2 VSS.n10 6.6005
R109 VSS.n24 VSS.n7 6.5635
R110 VSS.n6 VSS.n9 6.5635
R111 VSS.n21 VSS.n9 6.5635
R112 VSS.n25 VSS.n24 6.5635
R113 VSS.n14 VSS.n11 6.53249
R114 VSS.n16 VSS.n13 6.53249
R115 VSS.n2 VSS.n1 5.87219
R116 VSS VSS.n16 4.52391
R117 VSS.n14 VSS.n0 4.52391
R118 VSS.n24 VSS.n23 4.21975
R119 VSS.n23 VSS.n9 4.21975
R120 VSS VSS.n0 1.16544
R121 a_93_147.n1 a_93_147.t2 60.4767
R122 a_93_147.n1 a_93_147.t0 52.1434
R123 a_93_147.n2 a_93_147.n0 7.92328
R124 a_93_147.n0 a_93_147.n1 7.5005
R125 a_93_147.t4 a_93_147.n0 14.5939
R126 a_93_147.n2 a_93_147.t1 3.03552
R127 a_93_147.t3 a_93_147.n2 3.03552
C0 VDD Y 0.1271f
C1 Y VSS 0.39266f
C2 VDD VSS 2.29985f
C3 a_93_147.n0 VSS 0.2897f
C4 VSS.t1 VSS 0.11974f
C5 VDD.n0 VSS 0.10796f
C6 VDD.n28 VSS 0.10796f
C7 Y.t0 VSS 0.1272f
.ends
