* NGSPICE file created from gf180mcu_ocd_sc_rt12t3v3__xnor2_1.ext - technology: gf180mcuD

.subckt gf180mcu_ocd_sc_rt12t3v3__xnor2_1 A B Y VDD VSS
X0 VDD.t1 A.t4 AN.t1 VDD.t0 pfet_03v3 ad=0.5654p pd=3.45u as=0.3341p ps=1.805u w=1.285u l=0.28u
X1 VDD.t19 AN.t4 a_1313_987.t3 VDD.t18 pfet_03v3 ad=0.3341p pd=1.805u as=0.5654p ps=3.45u w=1.285u l=0.28u
X2 Y.t1 A.t3 a_540_987.t0 VDD.t4 pfet_03v3 ad=0.3341p pd=1.805u as=0.5654p ps=3.45u w=1.285u l=0.28u
X3 a_830_145# AN Y VSS.t5 nfet_03v3 ad=0.52065p pd=3.23u as=0.3087p ps=2.01u w=1.02u l=0.28u
X4 a_540_987.t3 B.t4 VDD.t9 VDD.t8 pfet_03v3 ad=0.5654p pd=3.45u as=0.3341p ps=1.805u w=1.285u l=0.28u
X5 a_1313_987.t0 AN.t3 VDD.t15 VDD.t14 pfet_03v3 ad=0.3341p pd=1.805u as=0.3341p ps=1.805u w=1.285u l=0.28u
X6 AN.t2 A.t1 VSS.t2 VSS.t0 nfet_03v3 ad=0.3087p pd=2.01u as=4.00512p ps=22.26u w=1.02u l=0.28u
X7 a_540_987.t1 A.t2 Y.t0 VDD.t5 pfet_03v3 ad=0.3341p pd=1.805u as=0.3341p ps=1.805u w=1.285u l=0.28u
X8 BN.t2 B.t0 VSS.t4 VSS.t0 nfet_03v3 ad=0.3087p pd=2.01u as=4.00512p ps=22.26u w=1.02u l=0.28u
X9 a_1411_203r# A.t0 VSS.t1 VSS.t0 nfet_03v3 ad=0.3087p pd=2.015u as=4.00512p ps=22.26u w=1.02u l=0.28u
X10 BN.t0 B.t3 VDD.t11 VDD.t10 pfet_03v3 ad=0.3341p pd=1.805u as=0.5654p ps=3.45u w=1.285u l=0.28u
X11 AN.t0 A.t5 VDD.t3 VDD.t2 pfet_03v3 ad=0.3341p pd=1.805u as=0.5654p ps=3.45u w=1.285u l=0.28u
X12 Y.t3 BN.t5 a_1313_987.t1 VDD.t16 pfet_03v3 ad=0.3341p pd=1.805u as=0.3341p ps=1.805u w=1.285u l=0.28u
X13 Y.t2 BN.t3 a_1411_203r# VSS.t6 nfet_03v3 ad=0.3087p pd=2.01u as=0.52065p ps=3.23u w=1.02u l=0.28u
X14 VDD.t7 B.t5 a_540_987.t2 VDD.t6 pfet_03v3 ad=0.3341p pd=1.805u as=0.3341p ps=1.805u w=1.285u l=0.28u
X15 a_830_145# B.t1 VSS.t3 VSS.t0 nfet_03v3 ad=0.3087p pd=2.01u as=4.00512p ps=22.26u w=1.02u l=0.28u
X16 a_1313_987.t2 BN.t4 Y.t4 VDD.t17 pfet_03v3 ad=0.5654p pd=3.45u as=0.3341p ps=1.805u w=1.285u l=0.28u
X17 VDD.t13 B.t2 BN.t1 VDD.t12 pfet_03v3 ad=0.5654p pd=3.45u as=0.3341p ps=1.805u w=1.285u l=0.28u
R0 Y.n0 Y.n3 4.01391
R1 Y.n14 Y.n10 210
R2 Y.n17 Y.n7 202.5
R3 Y.n26 Y.n21 202.5
R4 Y.n10 Y.n7 112.501
R5 Y.n18 Y.n17 112.501
R6 Y.n2 Y.n21 116.52
R7 Y.n1 Y.n0 3.41354
R8 Y.n25 Y.n22 37.861
R9 Y.n11 Y.n9 35.0626
R10 Y.n14 Y.n13 31.9491
R11 Y.n20 Y.n19 30.9092
R12 Y.n20 Y.n6 30.7604
R13 Y.n0 Y.n23 30.2684
R14 Y.n24 Y.n22 28.2205
R15 Y.n15 Y.n14 22.7684
R16 Y.n18 Y.n16 22.5005
R17 Y.n16 Y.n9 17.1346
R18 Y Y.n20 15.9101
R19 Y Y.n5 15.7295
R20 Y.n19 Y.t2 15.2591
R21 Y.n16 Y.n15 11.777
R22 Y.n24 Y.n23 11.2505
R23 Y.n11 Y.n4 10.8735
R24 Y.n15 Y.n8 7.5005
R25 Y.n17 Y.n8 7.5005
R26 Y.t2 Y.n18 7.5005
R27 Y.n2 Y.n24 7.57091
R28 Y.n27 Y.n26 7.5005
R29 Y.n27 Y.n22 7.5005
R30 Y Y.n1 47.2685
R31 Y.n26 Y.n25 6.85139
R32 Y.t2 Y.n4 0.489634
R33 Y.t2 Y.n9 4.82859
R34 Y.t2 Y.n8 4.42579
R35 Y.n10 Y.n8 4.16717
R36 Y.n2 Y.n0 3.65029
R37 Y.n27 Y.n3 0.0778758
R38 Y.n21 Y.n3 116.513
R39 Y.n19 Y.n7 3.87981
R40 Y.n1 Y.n21 1.89685
R41 Y.n4 Y.n7 9.25828
R42 Y.n25 Y.n0 4.50901
R43 Y.n5 Y.t1 3.03552
R44 Y.n5 Y.t0 3.03552
R45 Y.n6 Y.t3 3.03552
R46 Y.n6 Y.t4 3.03552
R47 Y.n13 Y.n12 2.72827
R48 Y.n13 Y.n11 2.38736
R49 B.n6 B.n5 307.5
R50 B.n0 B.t5 90.7743
R51 B.n2 B.t3 81.5648
R52 B.n2 B.t2 78.2772
R53 B.n8 B.n7 74.3292
R54 B.n0 B.t4 73.2743
R55 B.n5 B.n4 20.7085
R56 B.n8 B.n4 12.0226
R57 B.n1 B.t1 44.9023
R58 B.n7 B.n5 8.78735
R59 B B.n9 8.04598
R60 B.n1 B.n0 7.79541
R61 B B.n2 7.5005
R62 B.n9 B.n3 6.52414
R63 B.n9 B.n8 5.49555
R64 B.t0 B.n6 4.9219
R65 B.n4 B.n3 3.94768
R66 B B.n1 2.37695
R67 B.n7 B.t0 2.28378
R68 B.n6 B.n3 1.62891
R69 A.n7 A.n6 307.5
R70 A.n11 A.n10 255
R71 A.n0 A.t2 85.3938
R72 A.n1 A.t4 81.5648
R73 A.n1 A.t5 78.2772
R74 A.n13 A.n10 60.0005
R75 A.n9 A.n8 57.2132
R76 A.n0 A.t3 40.0194
R77 A A.n0 24.7895
R78 A.n15 A.n14 23.75
R79 A.n6 A.n3 20.7085
R80 A.n14 A.n9 20.4747
R81 A.n16 A.n15 17.8219
R82 A.n15 A.n5 16.7862
R83 A.n16 A.n3 12.0226
R84 A.n12 A.n9 11.5184
R85 A.n10 A.n5 10.0005
R86 A.n8 A.n6 8.78735
R87 A A.t1 15.3422
R88 A.n16 A.n4 8.16652
R89 A A.n1 8.11407
R90 A A.n17 7.58927
R91 A.n11 A.n4 7.5005
R92 A.n12 A.n11 7.5005
R93 A.n14 A.n13 6.8553
R94 A.n17 A.n16 6.6005
R95 A.n17 A.n2 5.53225
R96 A.t0 A.n7 4.92276
R97 A.n13 A.n12 4.01836
R98 A.n3 A.n2 3.9392
R99 A.n5 A.n4 3.7505
R100 A.n8 A.t0 2.28378
R101 A.n7 A.n2 1.64162
R102 VDD.n70 VDD.n69 864.886
R103 VDD.n72 VDD.n71 164.505
R104 VDD.n41 VDD.n40 164.505
R105 VDD.n42 VDD.n39 164.505
R106 VDD.n46 VDD.n45 164.505
R107 VDD.n50 VDD.n35 164.505
R108 VDD.n52 VDD.n51 164.505
R109 VDD.n55 VDD.n32 164.505
R110 VDD.n57 VDD.n31 164.505
R111 VDD.n61 VDD.n60 164.505
R112 VDD.n62 VDD.n29 164.505
R113 VDD.n68 VDD.n25 164.505
R114 VDD.n60 VDD.t17 157.161
R115 VDD.n72 VDD.t2 141.005
R116 VDD.n39 VDD.t4 141.005
R117 VDD.n51 VDD.t8 141.005
R118 VDD.t12 VDD.n25 141.005
R119 VDD.n56 VDD.t14 133.661
R120 VDD.n52 VDD.t18 124.847
R121 VDD.n42 VDD.t0 117.504
R122 VDD.n47 VDD.t5 117.504
R123 VDD.n47 VDD.t6 117.504
R124 VDD.t10 VDD.n61 117.504
R125 VDD.t16 VDD.n56 101.347
R126 VDD.n57 VDD.t16 63.1584
R127 VDD.t0 VDD.n41 47.0017
R128 VDD.t5 VDD.n46 47.0017
R129 VDD.t6 VDD.n35 47.0017
R130 VDD.n62 VDD.t10 47.0017
R131 VDD.t18 VDD.n32 39.6578
R132 VDD.t14 VDD.n55 30.8451
R133 VDD.n40 VDD.t2 23.5011
R134 VDD.n45 VDD.t4 23.5011
R135 VDD.t8 VDD.n50 23.5011
R136 VDD.n29 VDD.t12 23.5011
R137 VDD.n66 VDD.n65 23.3338
R138 VDD.n74 VDD.n73 23.3338
R139 VDD.n73 VDD.n12 6.5635
R140 VDD.n38 VDD.n18 23.3338
R141 VDD.n43 VDD.n38 23.3338
R142 VDD.n6 VDD.n5 6.5635
R143 VDD.n44 VDD.n5 23.3338
R144 VDD.n7 VDD.n37 6.5635
R145 VDD.n48 VDD.n37 23.3338
R146 VDD.n48 VDD.n16 23.3338
R147 VDD.n13 VDD.n16 6.5635
R148 VDD.n49 VDD.n34 23.3338
R149 VDD.n3 VDD.n34 6.5635
R150 VDD.n53 VDD.n15 23.3338
R151 VDD.n14 VDD.n15 6.5635
R152 VDD.n54 VDD.n30 23.3338
R153 VDD.n58 VDD.n30 23.3338
R154 VDD.n9 VDD.n8 6.5635
R155 VDD.n59 VDD.n8 23.3338
R156 VDD.n10 VDD.n28 6.5635
R157 VDD.n63 VDD.n28 23.3338
R158 VDD.n63 VDD.n27 23.3338
R159 VDD.n11 VDD.n27 6.5635
R160 VDD.n67 VDD.n64 23.3338
R161 VDD.n21 VDD.n20 23.3338
R162 VDD.n2 VDD.n17 11.7458
R163 VDD.n4 VDD.n26 11.7458
R164 VDD VDD.n33 15.2628
R165 VDD VDD.n36 15.2628
R166 VDD VDD.n74 15.0005
R167 VDD.n73 VDD.n72 15.0005
R168 VDD.n12 VDD 4.21975
R169 VDD.n40 VDD.n18 15.0005
R170 VDD.n12 VDD.n18 6.5635
R171 VDD.n41 VDD.n38 15.0005
R172 VDD.n38 VDD 15.0005
R173 VDD.n43 VDD.n42 15.0005
R174 VDD.n6 VDD.n43 6.5635
R175 VDD.n39 VDD.n5 15.0005
R176 VDD VDD.n6 4.21975
R177 VDD.n45 VDD.n44 15.0005
R178 VDD.n44 VDD.n7 6.5635
R179 VDD.n46 VDD.n37 15.0005
R180 VDD.n7 VDD 4.21975
R181 VDD.n48 VDD.n47 15.0005
R182 VDD VDD.n48 15.0005
R183 VDD.n16 VDD.n35 15.0005
R184 VDD VDD.n13 4.21975
R185 VDD.n50 VDD.n49 15.0005
R186 VDD.n49 VDD.n13 6.5635
R187 VDD.n51 VDD.n34 15.0005
R188 VDD.n3 VDD 4.21975
R189 VDD.n53 VDD.n52 15.0005
R190 VDD.n3 VDD.n53 6.5635
R191 VDD.n15 VDD.n32 15.0005
R192 VDD VDD.n14 4.21975
R193 VDD.n55 VDD.n54 15.0005
R194 VDD.n54 VDD.n14 6.5635
R195 VDD.n56 VDD.n30 15.0005
R196 VDD.n30 VDD.n0 15.0005
R197 VDD.n58 VDD.n57 15.0005
R198 VDD.n9 VDD.n58 6.5635
R199 VDD.n31 VDD.n8 15.0005
R200 VDD.n0 VDD.n9 4.21975
R201 VDD.n60 VDD.n59 15.0005
R202 VDD.n59 VDD.n10 6.5635
R203 VDD.n61 VDD.n28 15.0005
R204 VDD.n10 VDD.n0 4.21975
R205 VDD.n63 VDD.n62 15.0005
R206 VDD.n0 VDD.n63 15.0005
R207 VDD.n29 VDD.n27 15.0005
R208 VDD.n0 VDD.n11 4.21975
R209 VDD.n64 VDD.n25 15.0005
R210 VDD.n64 VDD.n11 6.5635
R211 VDD.n68 VDD.n67 15.0005
R212 VDD.n67 VDD.n4 5.18282
R213 VDD.n69 VDD.n68 15.0005
R214 VDD.n65 VDD.n1 15.0005
R215 VDD.n0 VDD.n66 15.0005
R216 VDD.n4 VDD.n0 4.91009
R217 VDD.n2 VDD 4.21975
R218 VDD VDD.n21 15.0005
R219 VDD.n71 VDD.n20 15.0005
R220 VDD.n71 VDD.n70 15.0005
R221 VDD.n24 VDD.n23 13.0955
R222 VDD.n0 VDD.t13 10.895
R223 VDD VDD.t3 10.895
R224 VDD.n0 VDD.t11 10.8927
R225 VDD VDD.t1 10.8927
R226 VDD.n31 VDD.t17 7.34444
R227 VDD.n70 VDD.n22 6.64275
R228 VDD.n69 VDD.n23 6.64275
R229 VDD.n65 VDD.n24 6.5635
R230 VDD.n66 VDD.n26 6.5635
R231 VDD.n21 VDD.n19 6.5635
R232 VDD.n2 VDD.n19 13.1265
R233 VDD.n22 VDD.n20 6.53249
R234 VDD.n74 VDD.n17 5.18282
R235 VDD.n71 VDD.n17 4.91009
R236 VDD.n1 VDD.n23 4.52391
R237 VDD.n22 VDD 4.52391
R238 VDD.n68 VDD.n24 4.21975
R239 VDD.n68 VDD.n26 4.21975
R240 VDD.n71 VDD.n19 4.21975
R241 VDD.n33 VDD.t19 3.03552
R242 VDD.n33 VDD.t15 3.03552
R243 VDD.n36 VDD.t7 3.03552
R244 VDD.n36 VDD.t9 3.03552
R245 VDD VDD.n0 2.46877
R246 VDD.n0 VDD.n1 1.01277
R247 VSS.n35 VSS.n32 129.322
R248 VSS.n50 VSS.n22 129.078
R249 VSS.n38 VSS.n32 129.078
R250 VSS.t6 VSS.n22 70.3019
R251 VSS.n38 VSS.t0 56.4721
R252 VSS.n16 VSS.n0 13.0338
R253 VSS.n49 VSS.n19 23.3338
R254 VSS.n18 VSS.n10 12.6707
R255 VSS.n15 VSS.n27 13.1265
R256 VSS.n46 VSS.n45 23.3338
R257 VSS.n52 VSS.n51 23.3338
R258 VSS.n37 VSS.n14 23.3338
R259 VSS.n37 VSS.n33 23.3338
R260 VSS.n40 VSS.n39 23.3338
R261 VSS.n39 VSS.n30 23.3338
R262 VSS.n17 VSS.n8 6.46182
R263 VSS.n36 VSS.n35 21.1554
R264 VSS.n35 VSS.n34 21.1554
R265 VSS.n20 VSS.n3 6.1077
R266 VSS.n9 VSS.n8 16.9885
R267 VSS.n12 VSS.n47 16.9885
R268 VSS.n5 VSS.n21 12.9154
R269 VSS.n51 VSS.n14 15.8338
R270 VSS.n23 VSS.n13 11.7458
R271 VSS VSS.n52 15.0005
R272 VSS.n51 VSS.n50 15.0005
R273 VSS.n51 VSS 15.0005
R274 VSS.n50 VSS.n3 15.0005
R275 VSS VSS.n20 4.44765
R276 VSS.n5 VSS 2.84997
R277 VSS VSS.n46 15.0005
R278 VSS.n45 VSS 15.0005
R279 VSS.n15 VSS.n26 13.1265
R280 VSS.n15 VSS 4.21975
R281 VSS VSS.n11 4.31912
R282 VSS.n47 VSS 15.0005
R283 VSS.n18 VSS 4.21975
R284 VSS VSS.n1 2.82413
R285 VSS.n48 VSS 15.0005
R286 VSS.n6 VSS 4.21975
R287 VSS.n6 VSS.n25 13.1265
R288 VSS VSS.n19 15.0005
R289 VSS.n50 VSS.n49 15.0005
R290 VSS.n49 VSS.n16 6.5635
R291 VSS VSS.n16 4.21975
R292 VSS.n50 VSS.n8 15.0005
R293 VSS VSS.n17 4.27059
R294 VSS VSS.n7 4.31912
R295 VSS VSS.n13 4.91009
R296 VSS.n17 VSS.n23 13.0248
R297 VSS.n32 VSS.n30 15.0005
R298 VSS.n39 VSS.n38 15.0005
R299 VSS.n39 VSS.n31 15.0005
R300 VSS.n40 VSS.n22 15.0005
R301 VSS.n40 VSS.n13 5.18282
R302 VSS.n22 VSS.n14 15.0005
R303 VSS VSS.n14 15.0005
R304 VSS.n38 VSS.n37 15.0005
R305 VSS.n37 VSS 15.0005
R306 VSS.n33 VSS.n32 15.0005
R307 VSS.n9 VSS.t4 10.9505
R308 VSS.n12 VSS.t3 10.9505
R309 VSS.n2 VSS.t1 10.5005
R310 VSS.n4 VSS.t2 10.5005
R311 VSS.n5 VSS.n4 3.22754
R312 VSS.n12 VSS.n11 1.02382
R313 VSS.n2 VSS.n1 3.26631
R314 VSS.n9 VSS.n7 1.02382
R315 VSS.n2 VSS.n42 6.6005
R316 VSS.n4 VSS.n44 6.6005
R317 VSS.n19 VSS.n25 6.5635
R318 VSS.n20 VSS.n27 12.6707
R319 VSS.n45 VSS.n26 6.5635
R320 VSS.n34 VSS.n30 6.53249
R321 VSS.n36 VSS.n33 6.53249
R322 VSS.n1 VSS.n0 13.0019
R323 VSS.n47 VSS.n28 6.46182
R324 VSS.n46 VSS.n28 6.46182
R325 VSS.n52 VSS.n21 6.46182
R326 VSS.n9 VSS.n41 6.3005
R327 VSS.n12 VSS.n43 6.3005
R328 VSS.n6 VSS.n24 12.6707
R329 VSS.n11 VSS.n10 8.15385
R330 VSS.n48 VSS.n29 6.09799
R331 VSS.n18 VSS.n29 12.661
R332 VSS VSS.n36 4.52391
R333 VSS.n34 VSS.n31 4.52391
R334 VSS.n50 VSS.n29 4.45251
R335 VSS.n50 VSS.n10 4.44765
R336 VSS.n50 VSS.n24 4.44765
R337 VSS.n50 VSS.n21 4.27059
R338 VSS.n50 VSS.n28 4.27059
R339 VSS.n50 VSS.n0 4.26612
R340 VSS.n50 VSS.n26 4.21975
R341 VSS.n50 VSS.n27 4.21975
R342 VSS.n50 VSS.n25 4.21975
R343 VSS.n50 VSS.n23 4.21975
R344 VSS.n24 VSS.n7 8.15385
R345 VSS.n4 VSS.n3 3.70351
R346 VSS.n2 VSS.n48 3.34207
R347 VSS.n31 VSS 1.41216
R348 VSS.t5 VSS.t6 1.15298
R349 VSS.t0 VSS.t5 1.15298
R350 a_1313_987.n0 a_1313_987.t3 11.571
R351 a_1313_987.n0 a_1313_987.t2 11.5552
R352 a_1313_987.n1 a_1313_987.n0 7.5005
R353 a_1313_987.n1 a_1313_987.t1 3.03552
R354 a_1313_987.t0 a_1313_987.n1 3.03552
R355 a_540_987.n0 a_540_987.t3 11.571
R356 a_540_987.n0 a_540_987.t0 11.5552
R357 a_540_987.n1 a_540_987.n0 7.5005
R358 a_540_987.n1 a_540_987.t2 3.03552
R359 a_540_987.t1 a_540_987.n1 3.03552
R360 BN.n9 BN.t2 120.001
R361 BN.n2 BN.n8 115.718
R362 BN.n7 BN.t5 80.6553
R363 BN.n11 BN.n10 67.4693
R364 BN.n0 BN.n7 43.1687
R365 BN.n7 BN.t4 39.6434
R366 BN.n10 BN.n9 34.8011
R367 BN.n0 BN.t3 24.8302
R368 BN.n9 BN.n8 20.0898
R369 BN.n0 BN.n1 15.0005
R370 BN.n1 BN.n2 5.1751
R371 BN.n5 BN.n2 2.89242
R372 BN BN.n6 9.06146
R373 BN.n5 BN.n4 1.97827
R374 BN.n10 BN.n3 7.5005
R375 BN.n11 BN.n8 4.52242
R376 BN.n4 BN.t2 1.09191
R377 BN.n4 BN.n3 1.96464
R378 BN.n6 BN.t0 3.03552
R379 BN.n6 BN.t1 3.03552
R380 BN.n1 BN.t2 14.0052
R381 BN.n1 BN.n3 4.18614
R382 BN BN.n0 1.73395
R383 BN.n5 BN.n11 1.72383
R384 AN.n10 AN.t2 120.001
R385 AN.n1 AN.n9 115.718
R386 AN.n12 AN.n11 67.4693
R387 AN.n6 AN.t3 64.0184
R388 AN.n6 AN.t4 48.6017
R389 AN.n8 AN.n6 40.1923
R390 AN.n11 AN.n10 34.8011
R391 AN.n10 AN.n9 20.0898
R392 AN.n8 AN.n7 19.5538
R393 AN AN.n0 15.0005
R394 AN.n0 AN.n1 5.1751
R395 AN.n4 AN.n1 2.89242
R396 AN AN.n5 9.06146
R397 AN.n4 AN.n3 1.97827
R398 AN.n11 AN.n2 7.5005
R399 AN.n12 AN.n9 4.52242
R400 AN.n3 AN.t2 1.09191
R401 AN.n3 AN.n2 1.96464
R402 AN.n5 AN.t0 3.03552
R403 AN.n5 AN.t1 3.03552
R404 AN.n0 AN.t2 14.0052
R405 AN.n0 AN.n2 4.18614
R406 AN AN.n8 2.03598
R407 AN.n4 AN.n12 1.72383
C0 B Y 0.32121f
C1 BN VDD 0.75491f
C2 AN VDD 0.77886f
C3 VDD Y 0.27866f
C4 B VDD 1.12264f
C5 AN A 0.86051f
C6 A Y 0.38307f
C7 a_1411_203r# A 0.10539f
C8 B A 0.28736f
C9 VDD A 0.95138f
C10 BN Y 0.29696f
C11 AN Y 0.29411f
C12 a_1411_203r# Y 0.10834f
C13 BN B 0.73256f
C14 AN B 0.41022f
C15 Y VSS 1.59949f
C16 B VSS 1.50661f
C17 A VSS 2.03385f
C18 VDD VSS 7.79669f
C19 a_1411_203r# VSS 0.22317f
C20 a_830_145# VSS 1.063f
C21 BN VSS 1.15087f
C22 AN.t2 VSS 0.22804f
C23 AN.t1 VSS 0.10318f
C24 AN.t0 VSS 0.10212f
C25 AN.n5 VSS 0.12132f
C26 AN.n6 VSS 0.41724f
C27 AN.n7 VSS 0.40675f
C28 AN.n8 VSS 0.5704f
C29 AN.n11 VSS 0.11455f
C30 BN.n0 VSS 0.51473f
C31 BN.n7 VSS 0.21222f
C32 a_540_987.t2 VSS 0.1146f
C33 a_540_987.t0 VSS 0.18657f
C34 a_540_987.t3 VSS 0.2034f
C35 a_540_987.n0 VSS 0.449f
C36 a_540_987.t1 VSS 0.10415f
C37 a_1313_987.t2 VSS 0.18022f
C38 a_1313_987.t3 VSS 0.19899f
C39 a_1313_987.n0 VSS 0.44964f
C40 a_1313_987.t0 VSS 0.10937f
C41 VSS.t3 VSS 0.33863f
C42 VSS.t2 VSS 0.21064f
C43 VDD.n0 VSS 0.23788f
C44 VDD.n25 VSS 0.12601f
C45 VDD.n39 VSS 0.12601f
C46 VDD.n42 VSS 0.11632f
C47 VDD.n51 VSS 0.12601f
C48 VDD.n52 VSS 0.11935f
C49 VDD.n60 VSS 0.13268f
C50 VDD.n61 VSS 0.11632f
C51 VDD.n68 VSS 0.20356f
C52 VDD.n71 VSS 0.22779f
C53 VDD.n72 VSS 0.12601f
C54 A.n0 VSS 0.11473f
C55 A.n1 VSS 0.15106f
C56 A.n8 VSS 0.1082f
C57 A.n9 VSS 0.12419f
C58 A.n17 VSS 0.11704f
C59 B.n0 VSS 0.17859f
C60 B.n1 VSS 0.42325f
C61 B.n2 VSS 0.16274f
C62 B.n7 VSS 0.15888f
C63 B.n8 VSS 0.27525f
C64 Y.t2 VSS 0.17504f
C65 Y.n6 VSS 0.10235f
C66 Y.n20 VSS 0.34702f
.ends
