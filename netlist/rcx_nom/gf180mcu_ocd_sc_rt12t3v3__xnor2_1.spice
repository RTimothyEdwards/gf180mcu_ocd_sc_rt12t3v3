* NGSPICE file created from gf180mcu_ocd_sc_rt12t3v3__xnor2_1.ext - technology: gf180mcuD

.subckt gf180mcu_ocd_sc_rt12t3v3__xnor2_1 A B Y VDD VSS
X0 VDD.t7 A.t4 AN.t1 VDD.t6 pfet_03v3 ad=0.5654p pd=3.45u as=0.3341p ps=1.805u w=1.285u l=0.28u
X1 VDD.t2 AN.t4 a_1313_987.t1 VDD.t1 pfet_03v3 ad=0.3341p pd=1.805u as=0.5654p ps=3.45u w=1.285u l=0.28u
X2 Y.t0 A.t3 a_540_987.t0 VDD.t10 pfet_03v3 ad=0.3341p pd=1.805u as=0.5654p ps=3.45u w=1.285u l=0.28u
X3 a_830_145# AN Y VSS nfet_03v3 ad=0.52065p pd=3.23u as=0.3087p ps=2.01u w=1.02u l=0.28u
X4 a_540_987.t3 B.t4 VDD.t15 VDD.t14 pfet_03v3 ad=0.5654p pd=3.45u as=0.3341p ps=1.805u w=1.285u l=0.28u
X5 a_1313_987.t3 AN.t3 VDD.t5 VDD.t4 pfet_03v3 ad=0.3341p pd=1.805u as=0.3341p ps=1.805u w=1.285u l=0.28u
X6 AN.t2 A.t1 VSS.t2 VSS.t1 nfet_03v3 ad=0.3087p pd=2.01u as=4.00512p ps=22.26u w=1.02u l=0.28u
X7 a_540_987.t1 A.t2 Y.t4 VDD.t11 pfet_03v3 ad=0.3341p pd=1.805u as=0.3341p ps=1.805u w=1.285u l=0.28u
X8 BN.t2 B.t0 VSS.t5 VSS.t1 nfet_03v3 ad=0.3087p pd=2.01u as=4.00512p ps=22.26u w=1.02u l=0.28u
X9 a_1411_203r# A.t0 VSS.t3 VSS.t1 nfet_03v3 ad=0.3087p pd=2.015u as=4.00512p ps=22.26u w=1.02u l=0.28u
X10 BN.t0 B.t3 VDD.t17 VDD.t16 pfet_03v3 ad=0.3341p pd=1.805u as=0.5654p ps=3.45u w=1.285u l=0.28u
X11 AN.t0 A.t5 VDD.t9 VDD.t8 pfet_03v3 ad=0.3341p pd=1.805u as=0.5654p ps=3.45u w=1.285u l=0.28u
X12 Y.t3 BN.t5 a_1313_987.t2 VDD.t3 pfet_03v3 ad=0.3341p pd=1.805u as=0.3341p ps=1.805u w=1.285u l=0.28u
X13 Y.t2 BN.t3 a_1411_203r# VSS.t0 nfet_03v3 ad=0.3087p pd=2.01u as=0.52065p ps=3.23u w=1.02u l=0.28u
X14 VDD.t13 B.t5 a_540_987.t2 VDD.t12 pfet_03v3 ad=0.3341p pd=1.805u as=0.3341p ps=1.805u w=1.285u l=0.28u
X15 a_830_145# B.t1 VSS.t4 VSS.t1 nfet_03v3 ad=0.3087p pd=2.01u as=4.00512p ps=22.26u w=1.02u l=0.28u
X16 a_1313_987.t0 BN.t4 Y.t1 VDD.t0 pfet_03v3 ad=0.5654p pd=3.45u as=0.3341p ps=1.805u w=1.285u l=0.28u
X17 VDD.t19 B.t2 BN.t1 VDD.t18 pfet_03v3 ad=0.5654p pd=3.45u as=0.3341p ps=1.805u w=1.285u l=0.28u
R0 Y.n0 Y.n2 1.68642
R1 Y.n0 Y.n1 0.152381
R2 Y.n13 Y.n9 88.7005
R3 Y.n16 Y.n6 85.0505
R4 Y.n25 Y.n20 85.0505
R5 Y.n9 Y.n6 47.2505
R6 Y.n17 Y.n16 47.2505
R7 Y.n24 Y.n21 18.4257
R8 Y.n10 Y.n8 17.0759
R9 Y Y.n27 16.1593
R10 Y.n13 Y.n12 15.5491
R11 Y.n0 Y.n22 14.7309
R12 Y.n23 Y.n21 13.736
R13 Y.n19 Y.n18 11.5868
R14 Y.n14 Y.n13 11.0809
R15 Y.n17 Y.n15 10.4505
R16 Y.n19 Y.n5 10.3581
R17 Y.n15 Y.n8 8.32713
R18 Y.n18 Y.t2 6.40912
R19 Y Y.n4 5.83138
R20 Y.n15 Y.n14 5.73172
R21 Y.n23 Y.n22 5.4755
R22 Y Y.n19 5.28766
R23 Y.n10 Y.n3 5.06743
R24 Y.n1 Y.n23 5.38578
R25 Y.n26 Y.n21 3.6505
R26 Y.n14 Y.n7 3.1505
R27 Y.n16 Y.n7 3.1505
R28 Y.t2 Y.n17 3.1505
R29 Y.n26 Y.n25 3.1505
R30 Y.n27 Y.n0 2.93326
R31 Y.n25 Y.n24 2.86474
R32 Y.t2 Y.n3 0.206238
R33 Y.t2 Y.n8 2.1221
R34 Y.t2 Y.n7 1.85912
R35 Y.n9 Y.n7 1.7505
R36 Y.n1 Y.n20 3.86742
R37 Y.n26 Y.n2 0.0332878
R38 Y.n20 Y.n2 48.9364
R39 Y.n24 Y.n0 1.71736
R40 Y.n18 Y.n6 1.62981
R41 Y.n27 Y.n20 1.62981
R42 Y.n3 Y.n6 3.88957
R43 Y.n4 Y.t0 1.41684
R44 Y.n4 Y.t4 1.41684
R45 Y.n5 Y.t3 1.41684
R46 Y.n5 Y.t1 1.41684
R47 Y.n12 Y.n11 1.32827
R48 Y.n12 Y.n10 1.16236
R49 B.n0 B.t5 44.1771
R50 B.n2 B.t3 39.6951
R51 B.n2 B.t2 38.0951
R52 B.n0 B.t4 35.6604
R53 B.n1 B.t1 16.9906
R54 B.n1 B.n0 4.25571
R55 B B.n2 4.0005
R56 B B.t0 8.58455
R57 B B.n1 2.05705
R58 A.n1 A.n0 2.50334
R59 A.n9 A.n8 124.1
R60 A.n2 A.t2 41.5588
R61 A.n3 A.t4 39.6951
R62 A.n3 A.t5 38.0951
R63 A.n11 A.n8 29.2005
R64 A.n7 A.n6 27.8461
R65 A.n2 A.t3 19.4766
R66 A A.n2 12.6999
R67 A.n13 A.n12 11.5588
R68 A.n12 A.n7 9.96489
R69 A.n14 A.n13 8.6736
R70 A.n13 A.n5 8.16955
R71 A.n10 A.n7 5.60586
R72 A A.n15 4.90745
R73 A.n8 A.n5 4.86717
R74 A A.t1 7.94065
R75 A A.n3 4.53147
R76 A.n6 A.n0 13.5619
R77 A.n14 A.n4 3.97515
R78 A.n9 A.n4 3.6505
R79 A.n10 A.n9 3.6505
R80 A.n12 A.n11 3.33676
R81 A.n15 A.n14 3.2125
R82 A.n14 A.n0 6.02051
R83 A.n15 A.n1 2.69287
R84 A.t0 A.n1 2.39646
R85 A.n11 A.n10 1.95586
R86 A.n5 A.n4 1.8255
R87 A.n6 A.t0 1.11195
R88 VDD.n68 VDD.n67 363.252
R89 VDD.n70 VDD.n69 137.088
R90 VDD.n41 VDD.n40 137.088
R91 VDD.n42 VDD.n39 137.088
R92 VDD.n46 VDD.n45 137.088
R93 VDD.n50 VDD.n35 137.088
R94 VDD.n52 VDD.n51 137.088
R95 VDD.n55 VDD.n32 137.088
R96 VDD.n57 VDD.n31 137.088
R97 VDD.n61 VDD.n60 137.088
R98 VDD.n62 VDD.n29 137.088
R99 VDD.n66 VDD.n25 137.088
R100 VDD.n60 VDD.t0 130.968
R101 VDD.n70 VDD.t8 117.504
R102 VDD.n39 VDD.t10 117.504
R103 VDD.n51 VDD.t14 117.504
R104 VDD.t18 VDD.n25 117.504
R105 VDD.n56 VDD.t4 111.383
R106 VDD.n52 VDD.t1 104.04
R107 VDD.n42 VDD.t6 97.9197
R108 VDD.n47 VDD.t11 97.9197
R109 VDD.n47 VDD.t12 97.9197
R110 VDD.t16 VDD.n61 97.9197
R111 VDD.t3 VDD.n56 84.4558
R112 VDD.n57 VDD.t3 52.6321
R113 VDD.t6 VDD.n41 39.1682
R114 VDD.t11 VDD.n46 39.1682
R115 VDD.t12 VDD.n35 39.1682
R116 VDD.n62 VDD.t16 39.1682
R117 VDD.t1 VDD.n32 33.0482
R118 VDD.t4 VDD.n55 25.7043
R119 VDD.n40 VDD.t8 19.5843
R120 VDD.n45 VDD.t10 19.5843
R121 VDD.t14 VDD.n50 19.5843
R122 VDD.n29 VDD.t18 19.5843
R123 VDD.n72 VDD.n71 9.8005
R124 VDD.n71 VDD.n13 2.75725
R125 VDD.n38 VDD.n19 9.8005
R126 VDD.n43 VDD.n38 9.8005
R127 VDD.n7 VDD.n6 2.75725
R128 VDD.n44 VDD.n6 9.8005
R129 VDD.n8 VDD.n37 2.75725
R130 VDD.n48 VDD.n37 9.8005
R131 VDD.n48 VDD.n17 9.8005
R132 VDD.n14 VDD.n17 2.75725
R133 VDD.n49 VDD.n34 9.8005
R134 VDD.n4 VDD.n34 2.75725
R135 VDD.n53 VDD.n16 9.8005
R136 VDD.n15 VDD.n16 2.75725
R137 VDD.n54 VDD.n30 9.8005
R138 VDD.n58 VDD.n30 9.8005
R139 VDD.n10 VDD.n9 2.75725
R140 VDD.n59 VDD.n9 9.8005
R141 VDD.n11 VDD.n28 2.75725
R142 VDD.n63 VDD.n28 9.8005
R143 VDD.n63 VDD.n27 9.8005
R144 VDD.n12 VDD.n27 2.75725
R145 VDD.n65 VDD.n64 9.8005
R146 VDD.n22 VDD.n21 9.8005
R147 VDD.n3 VDD.n18 4.93411
R148 VDD.n5 VDD.n26 4.93411
R149 VDD VDD.n72 6.3005
R150 VDD.n71 VDD.n70 6.3005
R151 VDD.n13 VDD 1.77287
R152 VDD.n40 VDD.n19 6.3005
R153 VDD.n13 VDD.n19 2.75725
R154 VDD.n41 VDD.n38 6.3005
R155 VDD.n38 VDD 6.3005
R156 VDD.n43 VDD.n42 6.3005
R157 VDD.n7 VDD.n43 2.75725
R158 VDD.n39 VDD.n6 6.3005
R159 VDD VDD.n7 1.77287
R160 VDD.n45 VDD.n44 6.3005
R161 VDD.n44 VDD.n8 2.75725
R162 VDD.n46 VDD.n37 6.3005
R163 VDD.n8 VDD 1.77287
R164 VDD.n48 VDD.n47 6.3005
R165 VDD VDD.n48 6.3005
R166 VDD.n17 VDD.n35 6.3005
R167 VDD VDD.n14 1.77287
R168 VDD.n50 VDD.n49 6.3005
R169 VDD.n49 VDD.n14 2.75725
R170 VDD.n51 VDD.n34 6.3005
R171 VDD.n4 VDD 1.77287
R172 VDD.n53 VDD.n52 6.3005
R173 VDD.n4 VDD.n53 2.75725
R174 VDD.n16 VDD.n32 6.3005
R175 VDD VDD.n15 1.77287
R176 VDD.n55 VDD.n54 6.3005
R177 VDD.n54 VDD.n15 2.75725
R178 VDD.n56 VDD.n30 6.3005
R179 VDD.n30 VDD.n1 6.3005
R180 VDD.n58 VDD.n57 6.3005
R181 VDD.n10 VDD.n58 2.75725
R182 VDD.n31 VDD.n9 6.3005
R183 VDD.n60 VDD.n59 6.3005
R184 VDD.n59 VDD.n11 2.75725
R185 VDD.n61 VDD.n28 6.3005
R186 VDD.n11 VDD.n1 1.77287
R187 VDD.n63 VDD.n62 6.3005
R188 VDD.n1 VDD.n63 6.3005
R189 VDD.n29 VDD.n27 6.3005
R190 VDD.n1 VDD.n12 1.77287
R191 VDD.n64 VDD.n25 6.3005
R192 VDD.n64 VDD.n12 2.75725
R193 VDD.n66 VDD.n65 6.3005
R194 VDD.n65 VDD.n5 2.17736
R195 VDD.n67 VDD.n66 6.3005
R196 VDD.n1 VDD.n2 1.77287
R197 VDD.n5 VDD.n1 2.06282
R198 VDD.n3 VDD 1.77287
R199 VDD VDD.n22 6.3005
R200 VDD.n69 VDD.n21 6.3005
R201 VDD.n69 VDD.n68 6.3005
R202 VDD.n31 VDD.t0 6.12045
R203 VDD.n24 VDD.n0 5.4873
R204 VDD VDD.n33 5.42746
R205 VDD VDD.n36 5.42746
R206 VDD.n1 VDD.t19 4.32793
R207 VDD VDD.t9 4.32793
R208 VDD.n1 VDD.t17 4.32597
R209 VDD VDD.t7 4.32597
R210 VDD.n67 VDD.n0 2.82549
R211 VDD.n68 VDD.n23 2.82549
R212 VDD.n2 VDD.n24 5.514
R213 VDD.n2 VDD.n26 5.514
R214 VDD.n22 VDD.n20 2.75725
R215 VDD.n3 VDD.n20 5.514
R216 VDD.n23 VDD.n21 2.73055
R217 VDD.n1 VDD.n10 2.64888
R218 VDD.n72 VDD.n18 2.17736
R219 VDD VDD.n1 2.1365
R220 VDD.n69 VDD.n18 2.06282
R221 VDD.n1 VDD.n0 2.03587
R222 VDD.n23 VDD 2.03587
R223 VDD.n66 VDD.n24 1.77287
R224 VDD.n66 VDD.n26 1.77287
R225 VDD.n69 VDD.n20 1.77287
R226 VDD.n33 VDD.t2 1.41684
R227 VDD.n33 VDD.t5 1.41684
R228 VDD.n36 VDD.t13 1.41684
R229 VDD.n36 VDD.t15 1.41684
R230 VSS.n38 VSS.n35 129.143
R231 VSS.n50 VSS.n24 129.078
R232 VSS.n41 VSS.n35 129.078
R233 VSS.t0 VSS.n24 70.3019
R234 VSS.n41 VSS.t1 56.4721
R235 VSS.n9 VSS.n27 5.28821
R236 VSS.n49 VSS.n19 2.66071
R237 VSS.n49 VSS.n22 10.8894
R238 VSS.n46 VSS.n31 10.8894
R239 VSS.n52 VSS.n51 10.8894
R240 VSS.n40 VSS.n8 10.8894
R241 VSS.n40 VSS.n36 10.8894
R242 VSS.n43 VSS.n42 10.8894
R243 VSS.n42 VSS.n33 10.8894
R244 VSS.n16 VSS.n11 2.62485
R245 VSS.n20 VSS.n14 2.62485
R246 VSS.n21 VSS.n4 2.4988
R247 VSS.n28 VSS.n0 5.15552
R248 VSS.n27 VSS.n1 5.18841
R249 VSS.n12 VSS.n11 7.92821
R250 VSS.n15 VSS.n14 7.92821
R251 VSS.n6 VSS.n23 5.15789
R252 VSS.n39 VSS.n38 7.81835
R253 VSS.n38 VSS.n37 7.81835
R254 VSS.n51 VSS.n8 7.38939
R255 VSS.n25 VSS.n7 4.82111
R256 VSS VSS.n52 5.2005
R257 VSS.n51 VSS.n50 5.2005
R258 VSS.n51 VSS 5.2005
R259 VSS.n50 VSS.n4 5.2005
R260 VSS VSS.n21 1.3521
R261 VSS.n6 VSS 1.00728
R262 VSS.n20 VSS.n29 5.28505
R263 VSS VSS.n18 1.27115
R264 VSS.n50 VSS.n31 5.2005
R265 VSS.n18 VSS.n31 2.66071
R266 VSS VSS.n46 5.2005
R267 VSS.n50 VSS.n13 5.2005
R268 VSS.n17 VSS.n13 2.4988
R269 VSS.n50 VSS.n14 5.2005
R270 VSS VSS.n20 1.28908
R271 VSS VSS.n0 1.35384
R272 VSS VSS.n17 1.3521
R273 VSS VSS.n1 0.996963
R274 VSS.n50 VSS.n2 5.2005
R275 VSS.n0 VSS.n2 2.49531
R276 VSS VSS.n22 5.2005
R277 VSS.n50 VSS.n49 5.2005
R278 VSS.n19 VSS 1.27115
R279 VSS.n19 VSS.n32 5.32092
R280 VSS.n9 VSS 1.27115
R281 VSS.n50 VSS.n11 5.2005
R282 VSS VSS.n16 1.28908
R283 VSS VSS.n10 1.63997
R284 VSS VSS.n7 1.52105
R285 VSS.n16 VSS.n25 5.28505
R286 VSS.n35 VSS.n33 5.2005
R287 VSS.n42 VSS.n41 5.2005
R288 VSS.n42 VSS.n34 5.2005
R289 VSS.n43 VSS.n24 5.2005
R290 VSS.n43 VSS.n7 2.1609
R291 VSS.n24 VSS.n8 5.2005
R292 VSS VSS.n8 5.2005
R293 VSS.n41 VSS.n40 5.2005
R294 VSS.n40 VSS 5.2005
R295 VSS.n36 VSS.n35 5.2005
R296 VSS.n12 VSS.t5 4.5995
R297 VSS.n15 VSS.t4 4.5995
R298 VSS.n3 VSS.t3 4.4105
R299 VSS.n5 VSS.t2 4.4105
R300 VSS.n6 VSS.n5 1.53514
R301 VSS VSS.n15 3.1505
R302 VSS.n3 VSS.n1 1.55171
R303 VSS.n12 VSS.n10 0.51919
R304 VSS.n3 VSS.n48 2.7725
R305 VSS.n5 VSS.n45 2.7725
R306 VSS.n46 VSS.n30 2.66071
R307 VSS.n9 VSS.n32 5.32092
R308 VSS.n17 VSS.n28 5.159
R309 VSS.n21 VSS.n30 5.159
R310 VSS.n18 VSS.n29 5.32092
R311 VSS.n12 VSS.n44 2.6465
R312 VSS.n15 VSS.n47 2.6465
R313 VSS.n37 VSS.n33 2.63361
R314 VSS.n39 VSS.n36 2.63361
R315 VSS.n52 VSS.n23 2.62485
R316 VSS.n22 VSS.n26 2.4988
R317 VSS.t1 VSS.t0 2.30546
R318 VSS.n15 VSS.n13 1.64457
R319 VSS.n26 VSS.n10 3.35472
R320 VSS.n5 VSS.n4 1.70757
R321 VSS.n3 VSS.n2 1.5389
R322 VSS VSS.n39 1.53032
R323 VSS.n37 VSS.n34 1.53032
R324 VSS.n50 VSS.n26 1.3521
R325 VSS.n50 VSS.n23 1.28908
R326 VSS.n50 VSS.n27 1.2875
R327 VSS.n50 VSS.n29 1.27115
R328 VSS.n50 VSS.n30 1.27115
R329 VSS.n50 VSS.n28 1.27115
R330 VSS.n50 VSS.n32 1.27115
R331 VSS.n50 VSS.n25 1.27115
R332 VSS.n34 VSS 1.22213
R333 a_1313_987.n1 a_1313_987.t1 4.91293
R334 a_1313_987.t0 a_1313_987.n1 4.89923
R335 a_1313_987.n1 a_1313_987.n0 2.6005
R336 a_1313_987.n0 a_1313_987.t2 1.41684
R337 a_1313_987.n0 a_1313_987.t3 1.41684
R338 a_540_987.n0 a_540_987.t3 4.91293
R339 a_540_987.n0 a_540_987.t0 4.89923
R340 a_540_987.n1 a_540_987.n0 2.6005
R341 a_540_987.n1 a_540_987.t2 1.41684
R342 a_540_987.t1 a_540_987.n1 1.41684
R343 BN.n8 BN.t2 50.9005
R344 BN.n7 BN.t5 39.2525
R345 BN.n2 BN.n9 32.5888
R346 BN.n7 BN.t4 19.2934
R347 BN.n9 BN.n8 16.9387
R348 BN.n3 BN.n7 16.1699
R349 BN.n3 BN.t3 12.5664
R350 BN.n8 BN.n0 11.9058
R351 BN.n3 BN.n4 6.3005
R352 BN.n4 BN.n0 3.31861
R353 BN BN.n6 3.95133
R354 BN.n9 BN.n5 3.6505
R355 BN.n2 BN.n0 0.0474974
R356 BN.n1 BN.t2 0.459182
R357 BN.n1 BN.n5 0.825727
R358 BN.n6 BN.t0 1.41684
R359 BN.n6 BN.t1 1.41684
R360 BN.n4 BN.t2 5.88322
R361 BN.n4 BN.n5 1.7588
R362 BN.n2 BN.n1 1.57306
R363 BN BN.n3 1.5006
R364 AN.n9 AN.t2 50.9005
R365 AN.n3 AN.n10 32.5888
R366 AN.n7 AN.t3 31.1559
R367 AN.n7 AN.t4 23.6531
R368 AN.n10 AN.n9 16.9387
R369 AN.n0 AN.n7 15.33
R370 AN.n0 AN.n8 9.86868
R371 AN.n9 AN.n1 11.9058
R372 AN AN.n4 6.3005
R373 AN.n4 AN.n1 3.31861
R374 AN AN.n6 3.95133
R375 AN.n10 AN.n5 3.6505
R376 AN.n3 AN.n1 0.0474974
R377 AN.n2 AN.t2 0.459182
R378 AN.n2 AN.n5 0.825727
R379 AN.n6 AN.t0 1.41684
R380 AN.n6 AN.t1 1.41684
R381 AN.n4 AN.t2 5.88322
R382 AN AN.n0 1.76197
R383 AN.n4 AN.n5 1.7588
R384 AN.n3 AN.n2 1.57306
C0 A AN 0.85558f
C1 A VDD 0.84956f
C2 B BN 0.73129f
C3 Y AN 0.26496f
C4 VDD Y 0.24083f
C5 B A 0.28384f
C6 VDD AN 0.73584f
C7 B Y 0.34326f
C8 A a_1411_203r# 0.10157f
C9 B AN 0.40931f
C10 a_1411_203r# Y 0.11013f
C11 B VDD 0.98845f
C12 BN Y 0.25946f
C13 VDD BN 0.71817f
C14 A Y 0.41565f
C15 Y VSS 1.5346f
C16 B VSS 1.5302f
C17 A VSS 1.84869f
C18 VDD VSS 7.78113f
C19 a_1411_203r# VSS 0.22651f
C20 a_830_145# VSS 0.99794f
C21 BN VSS 1.07404f
C22 AN.n0 VSS 0.58007f
C23 AN.t2 VSS 0.22573f
C24 AN.t1 VSS 0.10029f
C25 AN.n6 VSS 0.1472f
C26 AN.n7 VSS 0.37588f
C27 AN.n8 VSS 0.40459f
C28 AN.n10 VSS 0.11134f
C29 BN.n3 VSS 0.50323f
C30 BN.t2 VSS 0.2353f
C31 BN.n6 VSS 0.10881f
C32 BN.n7 VSS 0.18789f
C33 a_540_987.t2 VSS 0.11281f
C34 a_540_987.t0 VSS 0.19635f
C35 a_540_987.t3 VSS 0.21235f
C36 a_540_987.n0 VSS 0.44134f
C37 a_540_987.t1 VSS 0.1034f
C38 a_1313_987.t1 VSS 0.20895f
C39 a_1313_987.t3 VSS 0.10883f
C40 a_1313_987.n1 VSS 0.44153f
C41 a_1313_987.t0 VSS 0.18974f
C42 VSS.t5 VSS 0.22275f
C43 VSS.t2 VSS 0.20875f
C44 VSS.t4 VSS 0.30793f
C45 VDD.n1 VSS 0.24072f
C46 VDD.n25 VSS 0.11713f
C47 VDD.n39 VSS 0.11713f
C48 VDD.n42 VSS 0.10812f
C49 VDD.n51 VSS 0.11713f
C50 VDD.n52 VSS 0.11094f
C51 VDD.n60 VSS 0.12332f
C52 VDD.n61 VSS 0.10812f
C53 VDD.n66 VSS 0.18921f
C54 VDD.n69 VSS 0.21174f
C55 VDD.n70 VSS 0.11713f
C56 A.n2 VSS 0.11465f
C57 A.n3 VSS 0.14637f
C58 A.n6 VSS 0.10986f
C59 A.n7 VSS 0.12033f
C60 A.n15 VSS 0.14208f
C61 B.n0 VSS 0.17221f
C62 B.n1 VSS 0.43757f
C63 B.n2 VSS 0.15594f
C64 Y.t2 VSS 0.17168f
C65 Y.n5 VSS 0.10236f
C66 Y.n19 VSS 0.35016f
.ends
