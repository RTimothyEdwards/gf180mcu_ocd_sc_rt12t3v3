* NGSPICE file created from gf180mcu_ocd_sc_rt12t3v3__nand2_1.ext - technology: gf180mcuD

.subckt gf180mcu_ocd_sc_rt12t3v3__nand2_1 A B Y VDD VSS
X0 Y.t4 A.t0 a_193_203r# VSS.t2 nfet_03v3 ad=0.3087p pd=2.01u as=0.52065p ps=3.23u w=1.02u l=0.28u
X1 VDD.t3 B.t1 Y.t3 VDD.t2 pfet_03v3 ad=0.3341p pd=1.805u as=0.3341p ps=1.805u w=1.285u l=0.28u
X2 Y.t2 A.t2 VDD.t5 VDD.t4 pfet_03v3 ad=0.3341p pd=1.805u as=0.3341p ps=1.805u w=1.285u l=0.28u
X3 Y.t1 B.t2 VDD.t1 VDD.t0 pfet_03v3 ad=0.3341p pd=1.805u as=0.5654p ps=3.45u w=1.285u l=0.28u
X4 VDD.t7 A.t1 Y.t0 VDD.t6 pfet_03v3 ad=0.5654p pd=3.45u as=0.3341p ps=1.805u w=1.285u l=0.28u
X5 a_193_203r# B.t0 VSS.t1 VSS.t0 nfet_03v3 ad=0.3087p pd=2.01u as=5.19535p ps=29.85u w=1.02u l=0.28u
R0 Y.n11 Y.n7 88.7005
R1 Y.n14 Y.n4 85.0505
R2 Y.n7 Y.n4 47.2505
R3 Y.n15 Y.n14 47.2505
R4 Y.n8 Y.n6 17.0759
R5 Y.n11 Y.n10 15.5491
R6 Y.n12 Y.n11 11.0809
R7 Y.n15 Y.n13 10.4505
R8 Y.n13 Y.n6 8.32713
R9 Y Y.n16 6.43905
R10 Y.n16 Y.t4 6.40912
R11 Y.n13 Y.n12 5.73172
R12 Y.n8 Y.n0 5.06743
R13 Y.n3 Y.n2 3.3518
R14 Y.n12 Y.n5 3.1505
R15 Y.n14 Y.n5 3.1505
R16 Y.t4 Y.n15 3.1505
R17 Y.t4 Y.n0 0.206238
R18 Y.n3 Y.n1 2.72963
R19 Y.t4 Y.n6 2.1221
R20 Y.t4 Y.n5 1.85912
R21 Y.n7 Y.n5 1.7505
R22 Y.n16 Y.n4 1.62981
R23 Y.n0 Y.n4 3.88957
R24 Y Y.n3 1.50213
R25 Y.n2 Y.t1 1.41684
R26 Y.n2 Y.t3 1.41684
R27 Y.n1 Y.t2 1.41684
R28 Y.n1 Y.t0 1.41684
R29 Y.n10 Y.n9 1.32827
R30 Y.n10 Y.n8 1.16236
R31 A.n0 A.t1 40.1505
R32 A.n0 A.t2 19.2934
R33 A A.n0 9.82848
R34 A A.t0 9.53762
R35 B.n0 B.t1 40.1505
R36 B.n0 B.t2 19.2934
R37 B B.n0 10.0207
R38 B B.t0 7.28459
R39 VDD.n34 VDD.n33 137.088
R40 VDD.n24 VDD.n22 137.088
R41 VDD.n26 VDD.n21 137.088
R42 VDD.n30 VDD.n16 137.088
R43 VDD.n32 VDD.n31 122.707
R44 VDD.n34 VDD.t0 117.504
R45 VDD.t6 VDD.n16 117.504
R46 VDD.n25 VDD.t2 97.9197
R47 VDD.t4 VDD.n25 97.9197
R48 VDD.t2 VDD.n24 39.1682
R49 VDD.n26 VDD.t4 39.1682
R50 VDD.n22 VDD.t0 19.5843
R51 VDD.n21 VDD.t6 19.5843
R52 VDD.n36 VDD.n35 9.8005
R53 VDD.n35 VDD.n6 2.75725
R54 VDD.n23 VDD.n8 9.8005
R55 VDD.n4 VDD.n20 2.75725
R56 VDD.n27 VDD.n20 9.8005
R57 VDD.n27 VDD.n18 9.8005
R58 VDD.n5 VDD.n18 2.75725
R59 VDD.n29 VDD.n28 9.8005
R60 VDD.n13 VDD.n10 9.8005
R61 VDD.n12 VDD.n11 9.8005
R62 VDD.n3 VDD.n17 4.93411
R63 VDD VDD.n36 6.3005
R64 VDD.n35 VDD.n34 6.3005
R65 VDD.n6 VDD 1.77287
R66 VDD.n22 VDD.n8 6.3005
R67 VDD.n6 VDD.n8 2.75725
R68 VDD.n24 VDD.n23 6.3005
R69 VDD.n23 VDD.n4 2.75725
R70 VDD.n25 VDD.n20 6.3005
R71 VDD.n4 VDD.n1 1.77287
R72 VDD.n27 VDD.n26 6.3005
R73 VDD.n1 VDD.n27 6.3005
R74 VDD.n21 VDD.n18 6.3005
R75 VDD.n1 VDD.n5 1.77287
R76 VDD.n28 VDD.n16 6.3005
R77 VDD.n28 VDD.n5 2.75725
R78 VDD.n30 VDD.n29 6.3005
R79 VDD.n29 VDD.n3 2.17736
R80 VDD.n31 VDD.n30 6.3005
R81 VDD.n1 VDD.n2 1.77287
R82 VDD.n3 VDD.n1 2.06282
R83 VDD.n11 VDD 6.3005
R84 VDD VDD.n12 6.3005
R85 VDD VDD.n13 6.3005
R86 VDD.n33 VDD.n10 6.3005
R87 VDD.n33 VDD.n32 6.3005
R88 VDD.n15 VDD.n0 5.4873
R89 VDD.n1 VDD.n19 5.42159
R90 VDD.n1 VDD.t7 4.32793
R91 VDD VDD.t1 4.32793
R92 VDD.n31 VDD.n0 2.82549
R93 VDD.n32 VDD.n14 2.82549
R94 VDD.n2 VDD.n15 5.514
R95 VDD.n2 VDD.n17 5.514
R96 VDD.n13 VDD.n9 2.75725
R97 VDD.n12 VDD.n9 2.75725
R98 VDD.n14 VDD.n10 2.73055
R99 VDD.n11 VDD.n7 2.17736
R100 VDD.n36 VDD.n7 2.17736
R101 VDD.n33 VDD.n7 2.06282
R102 VDD.n1 VDD.n0 2.03587
R103 VDD.n14 VDD 2.03587
R104 VDD.n30 VDD.n15 1.77287
R105 VDD.n30 VDD.n17 1.77287
R106 VDD.n33 VDD.n9 1.77287
R107 VDD.n1 VDD 1.7525
R108 VDD.n19 VDD.t3 1.41684
R109 VDD.n19 VDD.t5 1.41684
R110 VSS.n31 VSS.n30 513.399
R111 VSS.n17 VSS.n16 513.399
R112 VSS.n17 VSS.n14 513.399
R113 VSS.n20 VSS.n14 513.399
R114 VSS.n22 VSS.n21 513.399
R115 VSS.n22 VSS.n12 513.399
R116 VSS.n21 VSS.t2 467.56
R117 VSS.n31 VSS.t0 316.291
R118 VSS.n16 VSS.t0 197.109
R119 VSS.n28 VSS.n27 149.174
R120 VSS.t2 VSS.n20 45.8397
R121 VSS.n19 VSS.n6 10.8894
R122 VSS.n8 VSS.n13 2.66071
R123 VSS.n23 VSS.n13 10.8894
R124 VSS.n10 VSS.n9 2.66071
R125 VSS.n32 VSS.n11 10.8894
R126 VSS.n18 VSS.n6 10.4384
R127 VSS.n32 VSS.n4 9.76841
R128 VSS.n7 VSS.n11 7.38939
R129 VSS.n24 VSS.n9 7.38939
R130 VSS.n18 VSS.n3 2.35671
R131 VSS VSS.n28 5.41963
R132 VSS.n27 VSS 5.41963
R133 VSS.n32 VSS.n31 5.2005
R134 VSS VSS.n32 5.2005
R135 VSS.n30 VSS.n11 5.2005
R136 VSS.n11 VSS 5.2005
R137 VSS.n18 VSS.n17 5.2005
R138 VSS.n16 VSS.n4 5.2005
R139 VSS.n4 VSS 5.2005
R140 VSS.n9 VSS.n12 5.2005
R141 VSS VSS.n10 1.27115
R142 VSS.n23 VSS.n22 5.2005
R143 VSS.n10 VSS.n23 2.66071
R144 VSS.n21 VSS.n13 5.2005
R145 VSS.n8 VSS 1.27115
R146 VSS.n20 VSS.n19 5.2005
R147 VSS.n19 VSS.n8 2.66071
R148 VSS.n6 VSS.n14 5.2005
R149 VSS VSS.n6 5.2005
R150 VSS.n2 VSS 1.27115
R151 VSS.n25 VSS.n2 5.32092
R152 VSS.n24 VSS 5.2005
R153 VSS VSS.n7 5.2005
R154 VSS VSS.n1 1.27115
R155 VSS.n5 VSS.t1 4.4105
R156 VSS.n5 VSS.n3 1.42802
R157 VSS.n5 VSS.n15 2.7725
R158 VSS.n5 VSS.n4 2.71962
R159 VSS.n28 VSS.n0 2.66071
R160 VSS.n27 VSS.n26 2.66071
R161 VSS.n29 VSS.n7 2.66071
R162 VSS.n29 VSS.n1 5.32092
R163 VSS.n1 VSS.n0 5.32092
R164 VSS.n25 VSS.n24 2.66071
R165 VSS.n26 VSS.n2 5.32092
R166 VSS VSS.n3 2.07094
R167 VSS.n26 VSS.n12 1.27115
R168 VSS.n25 VSS.n12 1.27115
R169 VSS.n30 VSS.n29 1.27115
R170 VSS.n30 VSS.n0 1.27115
C0 VDD B 0.4051f
C1 Y A 0.36608f
C2 A VDD 0.34923f
C3 Y VDD 0.49478f
C4 Y VSS 0.39064f
C5 A VSS 0.79438f
C6 B VSS 0.84391f
C7 VDD VSS 3.15514f
C8 a_193_203r# VSS 0.35334f
C9 VSS.t1 VSS 0.10513f
C10 VDD.n1 VSS 0.1133f
C11 VDD.n30 VSS 0.13145f
C12 VDD.n33 VSS 0.13145f
C13 Y.t4 VSS 0.17689f
C14 Y.n3 VSS 0.24105f
.ends
