* NGSPICE file created from gf180mcu_ocd_sc_rt12t3v3__dffsr_1.ext - technology: gf180mcuD

.subckt gf180mcu_ocd_sc_rt12t3v3__dffsr_1 D CLK SN RN Q QN VDD VSS
X0 R.t0 RN.t2 VDD.t21 VDD.t20 pfet_03v3 ad=0.3341p pd=1.805u as=0.3341p ps=1.805u w=1.285u l=0.28u
X1 in1.t2 CLKb a_4039_203r# VSS.t16 nfet_03v3 ad=0.3087p pd=2.01u as=0.52065p ps=3.23u w=1.02u l=0.28u
X2 in1.t3 CLKN a_2065_203r# VSS.t32 nfet_03v3 ad=0.3087p pd=2.01u as=0.52065p ps=3.23u w=1.02u l=0.28u
X3 a_4039_203r# out1 VSS.t19 VSS.t18 nfet_03v3 ad=0.3087p pd=2.01u as=2.74793p ps=14.86u w=1.02u l=0.28u
X4 QN.t1 out2 VSS.t9 VSS.t8 nfet_03v3 ad=0.3087p pd=2.01u as=2.74793p ps=14.86u w=1.02u l=0.28u
X5 VDD.t57 CLK.t1 CLKN VDD.t56 pfet_03v3 ad=0.3341p pd=1.805u as=0.3341p ps=1.805u w=1.285u l=0.28u
X6 a_3938_987.t1 out1 VDD.t40 VDD.t39 pfet_03v3 ad=0.3341p pd=1.805u as=0.3341p ps=1.805u w=1.285u l=0.28u
X7 a_5474_987.t2 R.t5 out2 VDD.t10 pfet_03v3 ad=0.5654p pd=3.45u as=0.3341p ps=1.805u w=1.285u l=0.28u
X8 VDD.t15 out2 a_6694_987.t0 VDD.t14 pfet_03v3 ad=0.3341p pd=1.805u as=0.5654p ps=3.45u w=1.285u l=0.28u
X9 a_4706_987.t1 out1 VDD.t44 VDD.t43 pfet_03v3 ad=0.3341p pd=1.805u as=0.3341p ps=1.805u w=1.285u l=0.28u
X10 a_2065_203r# D.t0 VSS.t25 VSS.t24 nfet_03v3 ad=0.3087p pd=2.01u as=2.9769p ps=16.1u w=1.02u l=0.28u
X11 out1 SNb a_2824_203r# VSS.t0 nfet_03v3 ad=0.3087p pd=2.01u as=0.52065p ps=3.23u w=1.02u l=0.28u
X12 VDD.t50 D.t2 a_1948_987.t2 VDD.t49 pfet_03v3 ad=0.3341p pd=1.805u as=0.5654p ps=3.45u w=1.285u l=0.28u
X13 VDD.t3 SNb a_2717_987.t0 VDD.t2 pfet_03v3 ad=0.3341p pd=1.805u as=0.5654p ps=3.45u w=1.285u l=0.28u
X14 a_1948_987.t1 CLKb in1.t1 VDD.t34 pfet_03v3 ad=0.5654p pd=3.45u as=0.3341p ps=1.805u w=1.285u l=0.28u
X15 a_2717_987.t4 R.t7 out1 VDD.t28 pfet_03v3 ad=0.5654p pd=3.45u as=0.3341p ps=1.805u w=1.285u l=0.28u
X16 VDD.t48 SN.t1 a_921_203r# VDD.t47 pfet_03v3 ad=0.3341p pd=1.805u as=0.3341p ps=1.805u w=1.285u l=0.28u
X17 in2.t3 CLKN a_4706_987.t3 VDD.t70 pfet_03v3 ad=0.3341p pd=1.805u as=0.3341p ps=1.805u w=1.285u l=0.28u
X18 VDD.t19 out2 QN.t2 VDD.t18 pfet_03v3 ad=0.3341p pd=1.805u as=0.3341p ps=1.805u w=1.285u l=0.28u
X19 a_6795_203r# out2 VSS.t7 VSS.t6 nfet_03v3 ad=0.3087p pd=2.01u as=2.74793p ps=14.86u w=1.02u l=0.28u
X20 a_1948_987.t3 D.t1 VDD.t52 VDD.t51 pfet_03v3 ad=0.3341p pd=1.805u as=0.3341p ps=1.805u w=1.285u l=0.28u
X21 SNb a_921_203r# VSS.t15 VSS.t14 nfet_03v3 ad=0.3087p pd=2.01u as=2.9769p ps=16.1u w=1.02u l=0.28u
X22 a_2824_203r# in1.t6 VSS.t35 VSS.t34 nfet_03v3 ad=0.3087p pd=2.015u as=2.9769p ps=16.1u w=1.02u l=0.28u
X23 VDD.t59 in1.t8 a_2717_987.t5 VDD.t58 pfet_03v3 ad=0.3341p pd=1.805u as=0.5654p ps=3.45u w=1.285u l=0.28u
X24 VDD.t7 SNb a_5474_987.t0 VDD.t6 pfet_03v3 ad=0.3341p pd=1.805u as=0.5654p ps=3.45u w=1.285u l=0.28u
X25 CLKN CLK.t0 VSS.t27 VSS.t26 nfet_03v3 ad=0.3087p pd=2.01u as=2.9769p ps=16.1u w=1.02u l=0.28u
X26 SNb a_921_203r# VDD.t30 VDD.t29 pfet_03v3 ad=0.3341p pd=1.805u as=0.3341p ps=1.805u w=1.285u l=0.28u
X27 VDD.t23 RN.t1 R.t1 VDD.t22 pfet_03v3 ad=0.5654p pd=3.45u as=0.3341p ps=1.805u w=1.285u l=0.28u
X28 a_4706_987.t2 CLKN in2.t4 VDD.t71 pfet_03v3 ad=0.5654p pd=3.45u as=0.3341p ps=1.805u w=1.285u l=0.28u
X29 VDD.t25 in2.t8 a_5474_987.t3 VDD.t24 pfet_03v3 ad=0.3341p pd=1.805u as=0.5654p ps=3.45u w=1.285u l=0.28u
X30 Q.t2 QN.t5 VDD.t61 VDD.t60 pfet_03v3 ad=0.3341p pd=1.805u as=0.3341p ps=1.805u w=1.285u l=0.28u
X31 a_5574_203r# in2.t6 VSS.t13 VSS.t12 nfet_03v3 ad=0.3087p pd=2.015u as=2.9769p ps=16.1u w=1.02u l=0.28u
X32 CLKb CLKN VDD.t65 VDD.t64 pfet_03v3 ad=0.3341p pd=1.805u as=0.3341p ps=1.805u w=1.285u l=0.28u
X33 a_5474_987.t1 SNb VDD.t1 VDD.t0 pfet_03v3 ad=0.3341p pd=1.805u as=0.3341p ps=1.805u w=1.285u l=0.28u
X34 a_2717_987.t2 in1.t7 VDD.t9 VDD.t8 pfet_03v3 ad=0.5654p pd=3.45u as=0.3341p ps=1.805u w=1.285u l=0.28u
X35 in1.t4 CLKN a_3938_987.t2 VDD.t68 pfet_03v3 ad=0.3341p pd=1.805u as=0.3341p ps=1.805u w=1.285u l=0.28u
X36 a_6694_987.t1 out2 VDD.t13 VDD.t12 pfet_03v3 ad=0.3341p pd=1.805u as=0.3341p ps=1.805u w=1.285u l=0.28u
X37 out2 SNb a_5574_203r# VSS.t1 nfet_03v3 ad=0.3087p pd=2.01u as=0.52065p ps=3.23u w=1.02u l=0.28u
X38 a_2717_987.t1 SNb VDD.t5 VDD.t4 pfet_03v3 ad=0.3341p pd=1.805u as=0.3341p ps=1.805u w=1.285u l=0.28u
X39 VDD.t63 QN.t4 Q.t0 VDD.t62 pfet_03v3 ad=0.5654p pd=3.45u as=0.3341p ps=1.805u w=1.285u l=0.28u
X40 a_921_203r# SN.t0 VSS.t23 VSS.t22 nfet_03v3 ad=0.3087p pd=2.01u as=2.9769p ps=16.1u w=1.02u l=0.28u
X41 Q.t1 QN.t3 VSS.t29 VSS.t28 nfet_03v3 ad=0.3087p pd=2.01u as=2.9769p ps=16.1u w=1.02u l=0.28u
X42 CLKN CLK.t2 VDD.t55 VDD.t54 pfet_03v3 ad=0.3341p pd=1.805u as=0.5654p ps=3.45u w=1.285u l=0.28u
X43 VDD.t67 CLKN CLKb VDD.t66 pfet_03v3 ad=0.5654p pd=3.45u as=0.3341p ps=1.805u w=1.285u l=0.28u
X44 VDD.t38 out1 a_4706_987.t0 VDD.t37 pfet_03v3 ad=0.3341p pd=1.805u as=0.5654p ps=3.45u w=1.285u l=0.28u
X45 in2.t0 CLKb a_6694_987.t3 VDD.t35 pfet_03v3 ad=0.3341p pd=1.805u as=0.3341p ps=1.805u w=1.285u l=0.28u
X46 CLKb CLKN VSS.t31 VSS.t30 nfet_03v3 ad=0.3087p pd=2.01u as=2.9769p ps=16.1u w=1.02u l=0.28u
X47 out1 R.t4 VSS.t3 VSS.t2 nfet_03v3 ad=0.3087p pd=2.01u as=2.74793p ps=14.86u w=1.02u l=0.28u
X48 a_921_203r# SN.t2 VDD.t46 VDD.t45 pfet_03v3 ad=0.3341p pd=1.805u as=0.5654p ps=3.45u w=1.285u l=0.28u
X49 in1.t0 CLKb a_1948_987.t0 VDD.t33 pfet_03v3 ad=0.3341p pd=1.805u as=0.3341p ps=1.805u w=1.285u l=0.28u
X50 out1 R.t8 a_2717_987.t3 VDD.t11 pfet_03v3 ad=0.3341p pd=1.805u as=0.3341p ps=1.805u w=1.285u l=0.28u
X51 in2.t2 CLKb a_4807_203r# VSS.t17 nfet_03v3 ad=0.3087p pd=2.01u as=0.52065p ps=3.23u w=1.02u l=0.28u
X52 VDD.t32 a_921_203r# SNb VDD.t31 pfet_03v3 ad=0.3341p pd=1.805u as=0.3341p ps=1.805u w=1.285u l=0.28u
X53 a_4807_203r# out1 VSS.t21 VSS.t20 nfet_03v3 ad=0.3087p pd=2.01u as=2.74793p ps=14.86u w=1.02u l=0.28u
X54 a_5474_987.t4 in2.t7 VDD.t27 VDD.t26 pfet_03v3 ad=0.5654p pd=3.45u as=0.3341p ps=1.805u w=1.285u l=0.28u
X55 a_6694_987.t2 CLKb in2.t1 VDD.t36 pfet_03v3 ad=0.5654p pd=3.45u as=0.3341p ps=1.805u w=1.285u l=0.28u
X56 QN.t0 out2 VDD.t17 VDD.t16 pfet_03v3 ad=0.3341p pd=1.805u as=0.5654p ps=3.45u w=1.285u l=0.28u
X57 R.t2 RN.t0 VSS.t11 VSS.t10 nfet_03v3 ad=0.3087p pd=2.015u as=2.9769p ps=16.1u w=1.02u l=0.28u
X58 out2 R.t3 VSS.t5 VSS.t4 nfet_03v3 ad=0.3087p pd=2.01u as=2.74793p ps=14.86u w=1.02u l=0.28u
X59 in2.t5 CLKN a_6795_203r# VSS.t33 nfet_03v3 ad=0.3087p pd=2.01u as=0.53235p ps=3.25u w=1.02u l=0.28u
X60 VDD.t42 out1 a_3938_987.t0 VDD.t41 pfet_03v3 ad=0.3341p pd=1.805u as=0.5654p ps=3.45u w=1.285u l=0.28u
X61 a_3938_987.t3 CLKN in1.t5 VDD.t69 pfet_03v3 ad=0.5654p pd=3.45u as=0.3341p ps=1.805u w=1.285u l=0.28u
X62 out2 R.t6 a_5474_987.t5 VDD.t53 pfet_03v3 ad=0.3341p pd=1.805u as=0.3341p ps=1.805u w=1.285u l=0.28u
R0 Q.n6 Q.t1 50.9005
R1 Q.n2 Q.n7 32.5888
R2 Q.n7 Q.n6 16.9387
R3 Q.n6 Q.n0 11.9058
R4 Q Q.n3 6.5781
R5 Q.n3 Q.n0 3.31861
R6 Q.n7 Q.n4 3.6505
R7 Q Q.n5 2.92662
R8 Q.n2 Q.n0 0.0474974
R9 Q.n1 Q.t1 0.459182
R10 Q.n1 Q.n4 0.825727
R11 Q.n5 Q.t2 1.41684
R12 Q.n5 Q.t0 1.41684
R13 Q.n3 Q.t1 5.88322
R14 Q.n3 Q.n4 1.7588
R15 Q.n2 Q.n1 1.57306
R16 QN.n7 QN.t1 50.9005
R17 QN.n6 QN.t4 41.6424
R18 QN.n6 QN.t5 38.1951
R19 QN.n2 QN.n8 32.5888
R20 QN.n8 QN.n7 16.9387
R21 QN.n7 QN.n0 11.9058
R22 QN QN.n3 6.68456
R23 QN.n3 QN.n0 3.31861
R24 QN QN.n6 4.18637
R25 QN.n8 QN.n4 3.6505
R26 QN QN.t3 6.4561
R27 QN.n2 QN.n0 0.0474974
R28 QN.n1 QN.t1 0.459182
R29 QN.n1 QN.n4 0.825727
R30 QN.n5 QN.t0 1.41684
R31 QN.n5 QN.t2 1.41684
R32 QN.n3 QN.t1 5.88322
R33 QN QN.n5 3.91966
R34 QN.n3 QN.n4 1.7588
R35 QN.n2 QN.n1 1.57306
R36 D.n0 D.t1 31.3586
R37 D.n0 D.t2 23.4503
R38 D D.n0 13.8634
R39 D D.t0 6.75352
R40 RN.n0 RN.t1 50.0576
R41 RN.n0 RN.t2 29.2005
R42 RN RN.n0 19.2581
R43 RN.t0 RN 11.4537
R44 SN.n0 SN.t1 49.409
R45 SN.n0 SN.t2 29.1449
R46 SN SN.t0 16.4078
R47 SN SN.n0 11.0962
R48 CLK.n0 CLK.t1 40.1505
R49 CLK CLK.n0 19.9339
R50 CLK.n0 CLK.t2 19.2934
R51 CLK CLK.t0 7.00022
R52 VDD.n205 VDD.n204 1181.11
R53 VDD.n207 VDD.n206 137.088
R54 VDD.n115 VDD.n114 137.088
R55 VDD.n119 VDD.n118 137.088
R56 VDD.n120 VDD.n110 137.088
R57 VDD.n124 VDD.n123 137.088
R58 VDD.t31 VDD.n104 137.088
R59 VDD.n128 VDD.t31 137.088
R60 VDD.n132 VDD.n101 137.088
R61 VDD.n133 VDD.n132 137.088
R62 VDD.n137 VDD.n97 137.088
R63 VDD.n139 VDD.n95 137.088
R64 VDD.n142 VDD.n95 137.088
R65 VDD.n144 VDD.n92 137.088
R66 VDD.n147 VDD.n92 137.088
R67 VDD.n149 VDD.n91 137.088
R68 VDD.n154 VDD.n153 137.088
R69 VDD.n154 VDD.n89 137.088
R70 VDD.n159 VDD.n158 137.088
R71 VDD.n163 VDD.n162 137.088
R72 VDD.n164 VDD.n163 137.088
R73 VDD.n169 VDD.n168 137.088
R74 VDD.n172 VDD.n77 137.088
R75 VDD.n174 VDD.n173 137.088
R76 VDD.n177 VDD.n73 137.088
R77 VDD.n179 VDD.n178 137.088
R78 VDD.n183 VDD.n182 137.088
R79 VDD.n184 VDD.n69 137.088
R80 VDD.n188 VDD.n187 137.088
R81 VDD.n192 VDD.n64 137.088
R82 VDD.n194 VDD.n193 137.088
R83 VDD.n197 VDD.n61 137.088
R84 VDD.n60 VDD.n56 137.088
R85 VDD.n203 VDD.n56 137.088
R86 VDD.t68 VDD.n85 129.744
R87 VDD.t37 VDD.n82 129.744
R88 VDD.t6 VDD.n177 129.744
R89 VDD.n199 VDD.t62 129.744
R90 VDD.t70 VDD.n167 124.847
R91 VDD.t24 VDD.n172 124.847
R92 VDD.n193 VDD.t36 124.847
R93 VDD.n198 VDD.t18 124.847
R94 VDD.n207 VDD.t54 117.504
R95 VDD.n120 VDD.t66 117.504
R96 VDD.n125 VDD.t47 117.504
R97 VDD.n129 VDD.t22 117.504
R98 VDD.n134 VDD.t51 117.504
R99 VDD.n152 VDD.t11 110.159
R100 VDD.n157 VDD.t41 110.159
R101 VDD.n72 VDD.t53 110.159
R102 VDD.n69 VDD.t14 110.159
R103 VDD.t4 VDD.n148 105.263
R104 VDD.n184 VDD.t10 105.263
R105 VDD.n189 VDD.t12 105.263
R106 VDD.t8 VDD.n143 99.1437
R107 VDD.t56 VDD.n113 97.9197
R108 VDD.n113 VDD.t64 97.9197
R109 VDD.n110 VDD.t45 97.9197
R110 VDD.n138 VDD.t33 97.9197
R111 VDD.t34 VDD.n138 97.9197
R112 VDD.n143 VDD.t58 96.6957
R113 VDD.n148 VDD.t2 90.5758
R114 VDD.t71 VDD.n77 90.5758
R115 VDD.t26 VDD.n73 90.5758
R116 VDD.n189 VDD.t35 90.5758
R117 VDD.n194 VDD.t16 90.5758
R118 VDD.t28 VDD.n152 85.6798
R119 VDD.t39 VDD.n157 85.6798
R120 VDD.t0 VDD.n72 85.6798
R121 VDD.n125 VDD.t29 78.3359
R122 VDD.n129 VDD.t20 78.3359
R123 VDD.n134 VDD.t49 78.3359
R124 VDD.n162 VDD.t69 70.9919
R125 VDD.n167 VDD.t43 70.9919
R126 VDD.t60 VDD.n198 70.9919
R127 VDD.n85 VDD.t69 66.096
R128 VDD.n82 VDD.t43 66.096
R129 VDD.n199 VDD.t60 66.096
R130 VDD.t29 VDD.n104 58.752
R131 VDD.t20 VDD.n128 58.752
R132 VDD.t49 VDD.n133 58.752
R133 VDD.n153 VDD.t28 51.4081
R134 VDD.n158 VDD.t39 51.4081
R135 VDD.n179 VDD.t0 51.4081
R136 VDD.t2 VDD.n147 46.5121
R137 VDD.n169 VDD.t71 46.5121
R138 VDD.n174 VDD.t26 46.5121
R139 VDD.t35 VDD.n64 46.5121
R140 VDD.t16 VDD.n61 46.5121
R141 VDD.t58 VDD.n142 40.3922
R142 VDD.n115 VDD.t56 39.1682
R143 VDD.n118 VDD.t64 39.1682
R144 VDD.n123 VDD.t45 39.1682
R145 VDD.t33 VDD.n137 39.1682
R146 VDD.n139 VDD.t34 39.1682
R147 VDD.n144 VDD.t8 37.9442
R148 VDD.n149 VDD.t4 31.8242
R149 VDD.t10 VDD.n183 31.8242
R150 VDD.t12 VDD.n188 31.8242
R151 VDD.n91 VDD.t11 26.9283
R152 VDD.n89 VDD.t41 26.9283
R153 VDD.n182 VDD.t53 26.9283
R154 VDD.n187 VDD.t14 26.9283
R155 VDD.n114 VDD.t54 19.5843
R156 VDD.t66 VDD.n119 19.5843
R157 VDD.t47 VDD.n124 19.5843
R158 VDD.t22 VDD.n101 19.5843
R159 VDD.t51 VDD.n97 19.5843
R160 VDD.n168 VDD.t70 12.2404
R161 VDD.n173 VDD.t24 12.2404
R162 VDD.t36 VDD.n192 12.2404
R163 VDD.t18 VDD.n197 12.2404
R164 VDD.n6 VDD.n55 5.514
R165 VDD.n209 VDD.n208 9.8005
R166 VDD.n208 VDD.n37 2.75725
R167 VDD.n116 VDD.n50 9.8005
R168 VDD.n116 VDD.n111 9.8005
R169 VDD.n117 VDD.n12 2.75725
R170 VDD.n117 VDD.n109 9.8005
R171 VDD.n121 VDD.n36 2.75725
R172 VDD.n121 VDD.n108 9.8005
R173 VDD.n122 VDD.n13 2.75725
R174 VDD.n122 VDD.n107 9.8005
R175 VDD.n126 VDD.n35 2.75725
R176 VDD.n126 VDD.n14 9.8005
R177 VDD.n127 VDD.n14 9.8005
R178 VDD.n40 VDD.n103 2.75725
R179 VDD.n130 VDD.n103 9.8005
R180 VDD.n130 VDD.n102 9.8005
R181 VDD.n44 VDD.n102 2.75725
R182 VDD.n131 VDD.n100 9.8005
R183 VDD.n135 VDD.n100 9.8005
R184 VDD.n135 VDD.n34 2.75725
R185 VDD.n136 VDD.n98 9.8005
R186 VDD.n15 VDD.n96 2.75725
R187 VDD.n140 VDD.n96 9.8005
R188 VDD.n17 VDD.n16 2.75725
R189 VDD.n141 VDD.n16 9.8005
R190 VDD.n141 VDD.n48 9.8005
R191 VDD.n30 VDD.n48 2.75725
R192 VDD.n145 VDD.n93 9.8005
R193 VDD.n10 VDD.n93 2.75725
R194 VDD.n146 VDD.n47 9.8005
R195 VDD.n32 VDD.n47 2.75725
R196 VDD.n150 VDD.n9 9.8005
R197 VDD.n151 VDD.n9 9.8005
R198 VDD.n18 VDD.n88 2.75725
R199 VDD.n155 VDD.n88 9.8005
R200 VDD.n155 VDD.n86 9.8005
R201 VDD.n33 VDD.n86 2.75725
R202 VDD.n156 VDD.n84 9.8005
R203 VDD.n19 VDD.n84 2.75725
R204 VDD.n160 VDD.n83 9.8005
R205 VDD.n161 VDD.n20 2.75725
R206 VDD.n161 VDD.n81 9.8005
R207 VDD.n165 VDD.n81 9.8005
R208 VDD.n165 VDD.n39 2.75725
R209 VDD.n166 VDD.n46 9.8005
R210 VDD.n166 VDD.n79 9.8005
R211 VDD.n170 VDD.n21 2.75725
R212 VDD.n170 VDD.n78 9.8005
R213 VDD.n171 VDD.n22 2.75725
R214 VDD.n171 VDD.n76 9.8005
R215 VDD.n175 VDD.n43 2.75725
R216 VDD.n175 VDD.n74 9.8005
R217 VDD.n176 VDD.n23 2.75725
R218 VDD.n176 VDD.n71 9.8005
R219 VDD.n180 VDD.n42 2.75725
R220 VDD.n180 VDD.n24 9.8005
R221 VDD.n181 VDD.n24 9.8005
R222 VDD.n25 VDD.n68 2.75725
R223 VDD.n185 VDD.n68 9.8005
R224 VDD.n27 VDD.n26 2.75725
R225 VDD.n186 VDD.n26 9.8005
R226 VDD.n45 VDD.n66 2.75725
R227 VDD.n190 VDD.n66 9.8005
R228 VDD.n190 VDD.n65 9.8005
R229 VDD.n191 VDD.n28 2.75725
R230 VDD.n191 VDD.n63 9.8005
R231 VDD.n195 VDD.n31 2.75725
R232 VDD.n195 VDD.n29 9.8005
R233 VDD.n196 VDD.n29 9.8005
R234 VDD.n38 VDD.n59 2.75725
R235 VDD.n200 VDD.n59 9.8005
R236 VDD.n200 VDD.n58 9.8005
R237 VDD.n41 VDD.n58 2.75725
R238 VDD.n202 VDD.n201 9.8005
R239 VDD.n53 VDD.n52 9.8005
R240 VDD.n8 VDD.n49 4.93411
R241 VDD.n159 VDD.t68 7.34444
R242 VDD.n164 VDD.t37 7.34444
R243 VDD.n178 VDD.t6 7.34444
R244 VDD.t62 VDD.n60 7.34444
R245 VDD.n11 VDD.n57 4.93411
R246 VDD VDD.n209 6.3005
R247 VDD.n208 VDD.n207 6.3005
R248 VDD.n37 VDD 1.77287
R249 VDD.n114 VDD.n50 6.3005
R250 VDD.n37 VDD.n50 2.75725
R251 VDD.n116 VDD.n115 6.3005
R252 VDD VDD.n116 6.3005
R253 VDD.n113 VDD.n111 6.3005
R254 VDD.n12 VDD.n111 2.75725
R255 VDD.n118 VDD.n117 6.3005
R256 VDD.n12 VDD 1.77287
R257 VDD.n119 VDD.n109 6.3005
R258 VDD.n36 VDD.n109 2.75725
R259 VDD.n121 VDD.n120 6.3005
R260 VDD VDD.n36 1.77287
R261 VDD.n110 VDD.n108 6.3005
R262 VDD.n13 VDD.n108 2.75725
R263 VDD.n123 VDD.n122 6.3005
R264 VDD.n13 VDD 1.77287
R265 VDD.n124 VDD.n107 6.3005
R266 VDD.n35 VDD.n107 2.75725
R267 VDD.n126 VDD.n125 6.3005
R268 VDD.n0 VDD.n35 1.77287
R269 VDD.n14 VDD.n104 6.3005
R270 VDD.n0 VDD.n14 6.3005
R271 VDD.t31 VDD.n127 6.3005
R272 VDD.n127 VDD.n40 2.75725
R273 VDD.n128 VDD.n103 6.3005
R274 VDD.n40 VDD.n0 1.77287
R275 VDD.n130 VDD.n129 6.3005
R276 VDD.n0 VDD.n130 6.3005
R277 VDD.n102 VDD.n101 6.3005
R278 VDD.n0 VDD.n44 1.77287
R279 VDD.n132 VDD.n131 6.3005
R280 VDD.n131 VDD.n44 2.75725
R281 VDD.n133 VDD.n100 6.3005
R282 VDD.n100 VDD.n0 6.3005
R283 VDD.n135 VDD.n134 6.3005
R284 VDD.n0 VDD.n34 1.77287
R285 VDD.n98 VDD.n97 6.3005
R286 VDD.n34 VDD.n98 2.75725
R287 VDD.n137 VDD.n136 6.3005
R288 VDD.n136 VDD.n15 2.75725
R289 VDD.n138 VDD.n96 6.3005
R290 VDD.n15 VDD.n0 1.77287
R291 VDD.n140 VDD.n139 6.3005
R292 VDD.n17 VDD.n140 2.75725
R293 VDD.n16 VDD.n95 6.3005
R294 VDD.n0 VDD.n17 1.77287
R295 VDD.n142 VDD.n141 6.3005
R296 VDD.n141 VDD.n0 6.3005
R297 VDD.n143 VDD.n48 6.3005
R298 VDD.n0 VDD.n30 1.77287
R299 VDD.n145 VDD.n144 6.3005
R300 VDD.n30 VDD.n145 2.75725
R301 VDD.n93 VDD.n92 6.3005
R302 VDD.n0 VDD.n10 1.77287
R303 VDD.n147 VDD.n146 6.3005
R304 VDD.n146 VDD.n10 2.75725
R305 VDD.n148 VDD.n47 6.3005
R306 VDD.n0 VDD.n32 1.77287
R307 VDD.n150 VDD.n149 6.3005
R308 VDD.n32 VDD.n150 2.75725
R309 VDD.n91 VDD.n9 6.3005
R310 VDD.n1 VDD.n9 6.3005
R311 VDD.n152 VDD.n151 6.3005
R312 VDD.n151 VDD.n18 2.75725
R313 VDD.n153 VDD.n88 6.3005
R314 VDD.n18 VDD.n1 1.77287
R315 VDD.n155 VDD.n154 6.3005
R316 VDD.n1 VDD.n155 6.3005
R317 VDD.n89 VDD.n86 6.3005
R318 VDD.n1 VDD.n33 1.77287
R319 VDD.n157 VDD.n156 6.3005
R320 VDD.n156 VDD.n33 2.75725
R321 VDD.n158 VDD.n84 6.3005
R322 VDD.n19 VDD.n1 1.77287
R323 VDD.n160 VDD.n159 6.3005
R324 VDD.n19 VDD.n160 2.75725
R325 VDD.n85 VDD.n83 6.3005
R326 VDD.n20 VDD.n83 2.75725
R327 VDD.n162 VDD.n161 6.3005
R328 VDD.n20 VDD.n1 1.77287
R329 VDD.n163 VDD.n81 6.3005
R330 VDD.n81 VDD.n1 6.3005
R331 VDD.n165 VDD.n164 6.3005
R332 VDD.n1 VDD.n39 1.77287
R333 VDD.n82 VDD.n46 6.3005
R334 VDD.n39 VDD.n46 2.75725
R335 VDD.n167 VDD.n166 6.3005
R336 VDD.n166 VDD.n1 6.3005
R337 VDD.n168 VDD.n79 6.3005
R338 VDD.n79 VDD.n21 2.75725
R339 VDD.n170 VDD.n169 6.3005
R340 VDD.n1 VDD.n21 1.77287
R341 VDD.n78 VDD.n77 6.3005
R342 VDD.n22 VDD.n78 2.75725
R343 VDD.n172 VDD.n171 6.3005
R344 VDD.n22 VDD.n7 1.77287
R345 VDD.n173 VDD.n76 6.3005
R346 VDD.n43 VDD.n76 2.75725
R347 VDD.n175 VDD.n174 6.3005
R348 VDD.n7 VDD.n43 1.77287
R349 VDD.n74 VDD.n73 6.3005
R350 VDD.n23 VDD.n74 2.75725
R351 VDD.n177 VDD.n176 6.3005
R352 VDD.n23 VDD.n7 1.77287
R353 VDD.n178 VDD.n71 6.3005
R354 VDD.n42 VDD.n71 2.75725
R355 VDD.n180 VDD.n179 6.3005
R356 VDD.n7 VDD.n42 1.77287
R357 VDD.n72 VDD.n24 6.3005
R358 VDD.n7 VDD.n24 6.3005
R359 VDD.n182 VDD.n181 6.3005
R360 VDD.n181 VDD.n25 2.75725
R361 VDD.n183 VDD.n68 6.3005
R362 VDD.n25 VDD.n7 1.77287
R363 VDD.n185 VDD.n184 6.3005
R364 VDD.n27 VDD.n185 2.75725
R365 VDD.n69 VDD.n26 6.3005
R366 VDD.n7 VDD.n27 1.77287
R367 VDD.n187 VDD.n186 6.3005
R368 VDD.n186 VDD.n45 2.75725
R369 VDD.n188 VDD.n66 6.3005
R370 VDD.n45 VDD.n4 1.77287
R371 VDD.n190 VDD.n189 6.3005
R372 VDD.n4 VDD.n190 6.3005
R373 VDD.n65 VDD.n64 6.3005
R374 VDD.n28 VDD.n65 2.75725
R375 VDD.n192 VDD.n191 6.3005
R376 VDD.n28 VDD.n4 1.77287
R377 VDD.n193 VDD.n63 6.3005
R378 VDD.n31 VDD.n63 2.75725
R379 VDD.n195 VDD.n194 6.3005
R380 VDD.n4 VDD.n31 1.77287
R381 VDD.n29 VDD.n61 6.3005
R382 VDD.n4 VDD.n29 6.3005
R383 VDD.n197 VDD.n196 6.3005
R384 VDD.n196 VDD.n38 2.75725
R385 VDD.n198 VDD.n59 6.3005
R386 VDD.n38 VDD.n5 1.77287
R387 VDD.n200 VDD.n199 6.3005
R388 VDD.n5 VDD.n200 6.3005
R389 VDD.n60 VDD.n58 6.3005
R390 VDD.n5 VDD.n41 1.77287
R391 VDD.n201 VDD.n56 6.3005
R392 VDD.n201 VDD.n41 2.75725
R393 VDD.n203 VDD.n202 6.3005
R394 VDD.n202 VDD.n11 2.17736
R395 VDD.n204 VDD.n203 6.3005
R396 VDD.n6 VDD.n5 1.77287
R397 VDD.n11 VDD.n5 2.06282
R398 VDD.n8 VDD.n2 1.77287
R399 VDD.n2 VDD.n53 6.3005
R400 VDD.n206 VDD.n52 6.3005
R401 VDD.n206 VDD.n205 6.3005
R402 VDD.n55 VDD.n3 5.4873
R403 VDD.n4 VDD.n67 5.42746
R404 VDD.n7 VDD.n70 5.42746
R405 VDD.n7 VDD.n75 5.42746
R406 VDD.n1 VDD.n80 5.42746
R407 VDD.n1 VDD.n87 5.42746
R408 VDD.n0 VDD.n90 5.42746
R409 VDD.n0 VDD.n94 5.42746
R410 VDD.n0 VDD.n99 5.42746
R411 VDD.n4 VDD.t17 4.32793
R412 VDD VDD.t55 4.32793
R413 VDD VDD.t46 4.32793
R414 VDD.n5 VDD.t63 4.32597
R415 VDD.n0 VDD.t23 4.32597
R416 VDD VDD.t67 4.32597
R417 VDD.n5 VDD.n62 2.91159
R418 VDD.n0 VDD.n105 2.91159
R419 VDD.n0 VDD.n106 2.91159
R420 VDD VDD.n112 2.91159
R421 VDD.n204 VDD.n3 2.82549
R422 VDD.n205 VDD.n54 2.82549
R423 VDD.n6 VDD.n57 5.514
R424 VDD.n53 VDD.n51 2.75725
R425 VDD.n8 VDD.n51 5.514
R426 VDD.n54 VDD.n52 2.73055
R427 VDD.n209 VDD.n49 2.17736
R428 VDD.n206 VDD.n49 2.06282
R429 VDD.n5 VDD.n3 2.03587
R430 VDD.n54 VDD.n2 2.03587
R431 VDD.n203 VDD.n55 1.77287
R432 VDD.n203 VDD.n57 1.77287
R433 VDD.n206 VDD.n51 1.77287
R434 VDD.n7 VDD.n1 1.5965
R435 VDD.n1 VDD.n0 1.4285
R436 VDD.n62 VDD.t19 1.41684
R437 VDD.n62 VDD.t61 1.41684
R438 VDD.n67 VDD.t15 1.41684
R439 VDD.n67 VDD.t13 1.41684
R440 VDD.n70 VDD.t7 1.41684
R441 VDD.n70 VDD.t1 1.41684
R442 VDD.n75 VDD.t25 1.41684
R443 VDD.n75 VDD.t27 1.41684
R444 VDD.n80 VDD.t38 1.41684
R445 VDD.n80 VDD.t44 1.41684
R446 VDD.n87 VDD.t42 1.41684
R447 VDD.n87 VDD.t40 1.41684
R448 VDD.n90 VDD.t3 1.41684
R449 VDD.n90 VDD.t5 1.41684
R450 VDD.n94 VDD.t59 1.41684
R451 VDD.n94 VDD.t9 1.41684
R452 VDD.n99 VDD.t50 1.41684
R453 VDD.n99 VDD.t52 1.41684
R454 VDD.n105 VDD.t32 1.41684
R455 VDD.n105 VDD.t21 1.41684
R456 VDD.n106 VDD.t48 1.41684
R457 VDD.n106 VDD.t30 1.41684
R458 VDD.n112 VDD.t57 1.41684
R459 VDD.n112 VDD.t65 1.41684
R460 VDD.n5 VDD.n4 1.1285
R461 VDD VDD.n2 1.1285
R462 VDD.n4 VDD.n7 1.0085
R463 VDD VDD.n0 1.0085
R464 VSS.n223 VSS.n222 1325.17
R465 VSS.n226 VSS.n225 513.399
R466 VSS.n127 VSS.n126 513.399
R467 VSS.n127 VSS.n125 513.399
R468 VSS.n131 VSS.n130 513.399
R469 VSS.n131 VSS.n121 513.399
R470 VSS.n134 VSS.n121 513.399
R471 VSS.n136 VSS.n135 513.399
R472 VSS.n136 VSS.n120 513.399
R473 VSS.n140 VSS.n139 513.399
R474 VSS.n140 VSS.n119 513.399
R475 VSS.n144 VSS.n143 513.399
R476 VSS.n144 VSS.n116 513.399
R477 VSS.n147 VSS.n116 513.399
R478 VSS.n148 VSS.n114 513.399
R479 VSS.n150 VSS.n114 513.399
R480 VSS.n152 VSS.n151 513.399
R481 VSS.n152 VSS.n112 513.399
R482 VSS.n155 VSS.n112 513.399
R483 VSS.n156 VSS.n110 513.399
R484 VSS.n159 VSS.n110 513.399
R485 VSS.n161 VSS.n160 513.399
R486 VSS.n161 VSS.n106 513.399
R487 VSS.n164 VSS.n106 513.399
R488 VSS.n166 VSS.n165 513.399
R489 VSS.n166 VSS.n105 513.399
R490 VSS.n170 VSS.n169 513.399
R491 VSS.n170 VSS.n102 513.399
R492 VSS.n173 VSS.n102 513.399
R493 VSS.n175 VSS.n174 513.399
R494 VSS.n175 VSS.n101 513.399
R495 VSS.n179 VSS.n178 513.399
R496 VSS.n180 VSS.n179 513.399
R497 VSS.n180 VSS.n98 513.399
R498 VSS.n184 VSS.n183 513.399
R499 VSS.n185 VSS.n184 513.399
R500 VSS.n189 VSS.n96 513.399
R501 VSS.n190 VSS.n189 513.399
R502 VSS.n191 VSS.n190 513.399
R503 VSS.n194 VSS.n94 513.399
R504 VSS.n195 VSS.n194 513.399
R505 VSS.n196 VSS.n92 513.399
R506 VSS.n200 VSS.n92 513.399
R507 VSS.n201 VSS.n200 513.399
R508 VSS.n202 VSS.n90 513.399
R509 VSS.n205 VSS.n90 513.399
R510 VSS.n206 VSS.n205 513.399
R511 VSS.n207 VSS.n86 513.399
R512 VSS.n210 VSS.n86 513.399
R513 VSS.n212 VSS.n211 513.399
R514 VSS.n212 VSS.n85 513.399
R515 VSS.n216 VSS.n215 513.399
R516 VSS.n217 VSS.n216 513.399
R517 VSS.n217 VSS.n82 513.399
R518 VSS.n207 VSS.t33 495.063
R519 VSS.n105 VSS.t18 490.481
R520 VSS.n165 VSS.t2 462.976
R521 VSS.n156 VSS.t34 458.392
R522 VSS.n135 VSS.t22 453.808
R523 VSS.t1 VSS.n94 421.721
R524 VSS.n101 VSS.t20 417.137
R525 VSS.t32 VSS.n150 412.553
R526 VSS.n119 VSS.t10 398.801
R527 VSS.n125 VSS.t30 380.466
R528 VSS.n183 VSS.t17 366.714
R529 VSS.t4 VSS.n195 362.13
R530 VSS.n148 VSS.t24 343.795
R531 VSS.n211 VSS.t8 343.795
R532 VSS.n185 VSS.t12 339.211
R533 VSS.n85 VSS.t28 325.459
R534 VSS.t0 VSS.n159 320.875
R535 VSS.n174 VSS.t16 293.372
R536 VSS.n126 VSS.t26 288.788
R537 VSS.t6 VSS.n201 288.788
R538 VSS.n139 VSS.t14 270.452
R539 VSS.n120 VSS.t14 242.948
R540 VSS.n226 VSS.t26 224.613
R541 VSS.n202 VSS.t6 224.613
R542 VSS.t16 VSS.n173 220.029
R543 VSS.n160 VSS.t0 192.525
R544 VSS.n215 VSS.t28 187.941
R545 VSS.t12 VSS.n96 174.19
R546 VSS.t24 VSS.n147 169.606
R547 VSS.t8 VSS.n210 169.606
R548 VSS.n196 VSS.t4 151.269
R549 VSS.n98 VSS.t17 146.685
R550 VSS.n130 VSS.t30 132.935
R551 VSS.n143 VSS.t10 114.599
R552 VSS.n151 VSS.t32 100.847
R553 VSS.n178 VSS.t20 96.2628
R554 VSS.n191 VSS.t1 91.6789
R555 VSS.t22 VSS.n134 59.5915
R556 VSS.t34 VSS.n155 55.0075
R557 VSS.t2 VSS.n164 50.4236
R558 VSS.n169 VSS.t18 22.9201
R559 VSS.t33 VSS.n206 18.3362
R560 VSS.n218 VSS.n49 2.66071
R561 VSS.n204 VSS.n89 10.8894
R562 VSS.n208 VSS.n48 2.66071
R563 VSS.n208 VSS.n88 10.8894
R564 VSS.n199 VSS.n75 10.8894
R565 VSS.n192 VSS.n95 10.8894
R566 VSS.n46 VSS.n45 2.66071
R567 VSS.n193 VSS.n45 10.8894
R568 VSS.n47 VSS.n70 2.66071
R569 VSS.n181 VSS.n42 10.8894
R570 VSS.n182 VSS.n42 10.8894
R571 VSS.n44 VSS.n43 2.66071
R572 VSS.n186 VSS.n43 10.8894
R573 VSS.n172 VSS.n67 10.8894
R574 VSS.n40 VSS.n100 2.66071
R575 VSS.n176 VSS.n100 10.8894
R576 VSS.n41 VSS.n66 2.66071
R577 VSS.n167 VSS.n104 10.8894
R578 VSS.n158 VSS.n71 10.8894
R579 VSS.n39 VSS.n109 2.66071
R580 VSS.n162 VSS.n109 10.8894
R581 VSS.n162 VSS.n108 10.8894
R582 VSS.n36 VSS.n113 2.66071
R583 VSS.n153 VSS.n113 10.8894
R584 VSS.n38 VSS.n37 2.66071
R585 VSS.n137 VSS.n80 10.8894
R586 VSS.n227 VSS.n81 10.8894
R587 VSS.n213 VSS.n72 10.8507
R588 VSS.n149 VSS.n5 10.8507
R589 VSS.n209 VSS.n51 2.6499
R590 VSS.n146 VSS.n62 10.7992
R591 VSS.n128 VSS.n53 2.63743
R592 VSS.n141 VSS.n56 2.63116
R593 VSS.n204 VSS.n32 2.61532
R594 VSS.n133 VSS.n60 10.49
R595 VSS.n154 VSS.n37 10.4771
R596 VSS.n59 VSS.n108 2.60894
R597 VSS.n218 VSS.n79 10.4126
R598 VSS.n34 VSS.n95 2.59768
R599 VSS.n199 VSS.n57 2.58958
R600 VSS.n64 VSS.n104 2.58307
R601 VSS.n61 VSS.n60 2.58307
R602 VSS.n63 VSS.n62 2.57652
R603 VSS.n181 VSS.n65 2.56994
R604 VSS.n177 VSS.n66 10.0519
R605 VSS.n142 VSS.n68 10.0003
R606 VSS.n35 VSS.n67 2.54328
R607 VSS.n129 VSS.n69 9.94879
R608 VSS.n197 VSS.n70 9.89725
R609 VSS.n187 VSS.n50 2.52805
R610 VSS.n214 VSS.n54 2.52293
R611 VSS.n167 VSS.n76 9.74264
R612 VSS.n157 VSS.n52 2.51436
R613 VSS.n55 VSS.n26 2.51264
R614 VSS.n203 VSS.n58 2.50919
R615 VSS.n138 VSS.n33 2.49182
R616 VSS VSS.n5 3.00215
R617 VSS.n209 VSS.n7 9.27761
R618 VSS.n146 VSS.n6 9.27761
R619 VSS.n128 VSS.n0 8.60291
R620 VSS.n141 VSS.n25 8.26556
R621 VSS.n15 VSS.n14 7.42219
R622 VSS.n31 VSS.n81 7.38939
R623 VSS.n219 VSS.n83 7.38939
R624 VSS.n133 VSS.n28 2.4182
R625 VSS.n154 VSS.n21 2.40308
R626 VSS.n163 VSS.n77 7.08484
R627 VSS.n13 VSS.n79 2.32493
R628 VSS.n188 VSS.n16 6.49448
R629 VSS.n198 VSS.n73 6.07279
R630 VSS.n2 VSS 6.0695
R631 VSS.n2 VSS 5.792
R632 VSS.n168 VSS.n20 5.73544
R633 VSS.n132 VSS.n30 5.73544
R634 VSS VSS.n223 5.41963
R635 VSS.n222 VSS.n4 5.41963
R636 VSS.n145 VSS.n24 5.39809
R637 VSS.n2 VSS 5.2235
R638 VSS.n227 VSS.n226 5.2005
R639 VSS.n1 VSS.n227 3.00607
R640 VSS.n225 VSS.n81 5.2005
R641 VSS.n81 VSS 5.2005
R642 VSS.n128 VSS.n127 5.2005
R643 VSS VSS.n53 1.28278
R644 VSS.n126 VSS.n0 5.2005
R645 VSS.n1 VSS 0.552811
R646 VSS.n125 VSS.n69 5.2005
R647 VSS.n53 VSS.n69 2.63743
R648 VSS.n132 VSS.n131 5.2005
R649 VSS.n61 VSS.n132 2.58307
R650 VSS.n130 VSS.n129 5.2005
R651 VSS.n29 VSS 1.35911
R652 VSS.n60 VSS.n121 5.2005
R653 VSS VSS.n61 1.30997
R654 VSS.n135 VSS.n26 5.2005
R655 VSS VSS.n55 1.34518
R656 VSS.n134 VSS.n133 5.2005
R657 VSS.n28 VSS 1.0508
R658 VSS.n120 VSS.n80 5.2005
R659 VSS.n33 VSS.n80 2.49182
R660 VSS.n137 VSS.n136 5.2005
R661 VSS.n55 VSS.n137 2.51264
R662 VSS.n141 VSS.n140 5.2005
R663 VSS VSS.n56 1.28592
R664 VSS.n139 VSS.n138 5.2005
R665 VSS.n33 VSS 1.35559
R666 VSS.n119 VSS.n68 5.2005
R667 VSS.n56 VSS.n68 2.63116
R668 VSS.n145 VSS.n144 5.2005
R669 VSS.n63 VSS.n145 2.57652
R670 VSS.n143 VSS.n142 5.2005
R671 VSS.n23 VSS 1.32216
R672 VSS.n62 VSS.n116 5.2005
R673 VSS VSS.n63 1.31324
R674 VSS.n6 VSS.n148 5.2005
R675 VSS.n147 VSS.n146 5.2005
R676 VSS.n146 VSS 5.2005
R677 VSS.n37 VSS.n112 5.2005
R678 VSS.n3 VSS.n38 1.27115
R679 VSS.n153 VSS.n152 5.2005
R680 VSS.n38 VSS.n153 2.66071
R681 VSS.n151 VSS.n113 5.2005
R682 VSS.n36 VSS 1.27115
R683 VSS.n150 VSS.n149 5.2005
R684 VSS.n149 VSS.n36 2.66071
R685 VSS.n5 VSS.n114 5.2005
R686 VSS.n157 VSS.n156 5.2005
R687 VSS.n3 VSS.n52 1.34432
R688 VSS.n155 VSS.n154 5.2005
R689 VSS.n21 VSS.n3 1.0565
R690 VSS.n108 VSS.n106 5.2005
R691 VSS.n3 VSS.n59 1.29703
R692 VSS.n162 VSS.n161 5.2005
R693 VSS.n3 VSS.n162 5.2005
R694 VSS.n160 VSS.n109 5.2005
R695 VSS.n39 VSS.n3 1.27115
R696 VSS.n159 VSS.n158 5.2005
R697 VSS.n158 VSS.n39 2.66071
R698 VSS.n71 VSS.n110 5.2005
R699 VSS.n52 VSS.n71 2.51436
R700 VSS.n165 VSS.n76 5.2005
R701 VSS.n3 VSS.n78 1.53021
R702 VSS.n164 VSS.n163 5.2005
R703 VSS.n163 VSS.n59 2.60894
R704 VSS.n105 VSS.n104 5.2005
R705 VSS.n3 VSS.n64 1.30997
R706 VSS.n167 VSS.n166 5.2005
R707 VSS.n3 VSS.n167 5.2005
R708 VSS.n171 VSS.n170 5.2005
R709 VSS.n35 VSS.n171 2.54328
R710 VSS.n169 VSS.n168 5.2005
R711 VSS.n168 VSS.n64 2.58307
R712 VSS.n101 VSS.n66 5.2005
R713 VSS.n3 VSS.n41 1.27115
R714 VSS.n176 VSS.n175 5.2005
R715 VSS.n41 VSS.n176 2.66071
R716 VSS.n174 VSS.n100 5.2005
R717 VSS.n40 VSS.n3 1.27115
R718 VSS.n173 VSS.n172 5.2005
R719 VSS.n172 VSS.n40 2.66071
R720 VSS.n67 VSS.n102 5.2005
R721 VSS.n3 VSS.n35 1.32986
R722 VSS.n179 VSS.n17 5.2005
R723 VSS.n65 VSS.n17 2.56994
R724 VSS.n178 VSS.n177 5.2005
R725 VSS.n19 VSS.n3 1.28716
R726 VSS.n186 VSS.n185 5.2005
R727 VSS.n186 VSS.n50 2.52805
R728 VSS.n184 VSS.n43 5.2005
R729 VSS.n2 VSS.n44 1.27115
R730 VSS.n183 VSS.n182 5.2005
R731 VSS.n182 VSS.n44 2.66071
R732 VSS.n98 VSS.n42 5.2005
R733 VSS.n2 VSS.n42 5.2005
R734 VSS.n181 VSS.n180 5.2005
R735 VSS.n2 VSS.n65 1.31653
R736 VSS.n189 VSS.n188 5.2005
R737 VSS.n188 VSS.n34 2.59768
R738 VSS.n187 VSS.n96 5.2005
R739 VSS.n2 VSS.n50 1.33747
R740 VSS.n195 VSS.n70 5.2005
R741 VSS.n2 VSS.n47 1.27115
R742 VSS.n194 VSS.n193 5.2005
R743 VSS.n193 VSS.n47 2.66071
R744 VSS.n45 VSS.n94 5.2005
R745 VSS.n2 VSS.n46 1.27115
R746 VSS.n192 VSS.n191 5.2005
R747 VSS.n46 VSS.n192 2.66071
R748 VSS.n190 VSS.n95 5.2005
R749 VSS.n34 VSS.n2 1.30266
R750 VSS.n73 VSS.n92 5.2005
R751 VSS.n57 VSS.n73 2.58958
R752 VSS.n197 VSS.n196 5.2005
R753 VSS.n74 VSS.n2 1.39819
R754 VSS.n201 VSS.n75 5.2005
R755 VSS.n58 VSS.n75 2.50919
R756 VSS.n200 VSS.n199 5.2005
R757 VSS.n57 VSS.n2 1.30671
R758 VSS.n14 VSS.n90 5.2005
R759 VSS.n32 VSS.n14 2.61532
R760 VSS.n203 VSS.n202 5.2005
R761 VSS.n58 VSS.n2 1.3469
R762 VSS.n88 VSS.n86 5.2005
R763 VSS.n51 VSS.n88 2.6499
R764 VSS.n208 VSS.n207 5.2005
R765 VSS.n2 VSS.n48 1.27115
R766 VSS.n206 VSS.n89 5.2005
R767 VSS.n89 VSS.n48 2.66071
R768 VSS.n205 VSS.n204 5.2005
R769 VSS.n32 VSS.n2 1.29384
R770 VSS.n211 VSS.n7 5.2005
R771 VSS.n210 VSS.n209 5.2005
R772 VSS.n51 VSS.n2 1.27655
R773 VSS.n85 VSS.n72 5.2005
R774 VSS.n54 VSS.n72 2.52293
R775 VSS.n213 VSS.n212 5.2005
R776 VSS.n216 VSS.n79 5.2005
R777 VSS.n2 VSS.n13 1.08598
R778 VSS.n215 VSS.n214 5.2005
R779 VSS.n54 VSS.n2 1.34003
R780 VSS.n83 VSS.n82 5.2005
R781 VSS.n49 VSS.n83 2.66071
R782 VSS.n218 VSS.n217 5.2005
R783 VSS.n2 VSS.n49 1.27115
R784 VSS.n11 VSS.n4 1.27115
R785 VSS.n220 VSS.n11 5.32092
R786 VSS.n219 VSS.n4 5.2005
R787 VSS VSS.n31 5.2005
R788 VSS VSS.n10 1.27115
R789 VSS.n18 VSS.n17 5.06074
R790 VSS.n2 VSS 4.90325
R791 VSS.n198 VSS.t5 4.5995
R792 VSS.n77 VSS.t3 4.5995
R793 VSS.n12 VSS.t29 4.4105
R794 VSS.n7 VSS.t9 4.4105
R795 VSS.n15 VSS.t7 4.4105
R796 VSS.n16 VSS.t13 4.4105
R797 VSS.n18 VSS.t21 4.4105
R798 VSS.n20 VSS.t19 4.4105
R799 VSS.n22 VSS.t35 4.4105
R800 VSS.n6 VSS.t25 4.4105
R801 VSS.n24 VSS.t11 4.4105
R802 VSS.n25 VSS.t15 4.4105
R803 VSS.n27 VSS.t23 4.4105
R804 VSS.n30 VSS.t31 4.4105
R805 VSS.n0 VSS.t27 4.4105
R806 VSS.n177 VSS.n19 1.79164
R807 VSS.n2 VSS 4.30775
R808 VSS.n142 VSS.n23 1.69888
R809 VSS.n2 VSS 4.00219
R810 VSS.n2 VSS 3.81406
R811 VSS.n2 VSS 3.7325
R812 VSS.n171 VSS.n20 3.71134
R813 VSS.n129 VSS.n29 1.60092
R814 VSS.n2 VSS 3.42864
R815 VSS.n74 VSS.n197 1.49733
R816 VSS.n2 VSS 3.20897
R817 VSS.n3 VSS 3.1565
R818 VSS.n30 VSS.n29 0.970182
R819 VSS.n28 VSS.n27 1.46527
R820 VSS.n25 VSS 3.1505
R821 VSS.n24 VSS.n23 1.02952
R822 VSS.n6 VSS 1.21585
R823 VSS.n22 VSS.n21 1.45611
R824 VSS.n78 VSS.n77 0.695449
R825 VSS.n20 VSS.n3 3.1505
R826 VSS.n19 VSS.n18 1.08572
R827 VSS.n2 VSS.n16 3.1505
R828 VSS.n74 VSS.n198 0.907428
R829 VSS.n2 VSS.n15 3.1505
R830 VSS.n8 VSS.n7 1.21585
R831 VSS.n13 VSS.n12 1.40876
R832 VSS.n30 VSS.n123 2.9615
R833 VSS.n24 VSS.n117 2.9615
R834 VSS.n20 VSS.n103 2.9615
R835 VSS.n18 VSS.n99 2.9615
R836 VSS.n16 VSS.n97 2.9615
R837 VSS.n187 VSS.n16 2.95231
R838 VSS.n214 VSS.n12 2.8883
R839 VSS.n3 VSS 2.83625
R840 VSS.n2 VSS 2.80779
R841 VSS.n12 VSS.n84 2.7725
R842 VSS.n7 VSS.n87 2.7725
R843 VSS.n15 VSS.n91 2.7725
R844 VSS.n198 VSS.n93 2.7725
R845 VSS.n77 VSS.n107 2.7725
R846 VSS.n22 VSS.n111 2.7725
R847 VSS.n6 VSS.n115 2.7725
R848 VSS.n25 VSS.n118 2.7725
R849 VSS.n27 VSS.n122 2.7725
R850 VSS.n0 VSS.n124 2.7725
R851 VSS.n223 VSS.n9 2.66071
R852 VSS.n222 VSS.n221 2.66071
R853 VSS.n224 VSS.n31 2.66071
R854 VSS.n224 VSS.n10 5.32092
R855 VSS.n10 VSS.n9 5.32092
R856 VSS.n220 VSS.n219 2.66071
R857 VSS.n221 VSS.n11 5.32092
R858 VSS.n213 VSS.n8 3.00215
R859 VSS.n157 VSS.n22 2.46661
R860 VSS.n3 VSS 2.41779
R861 VSS.n27 VSS.n26 2.38227
R862 VSS.n78 VSS.n76 1.14739
R863 VSS.n3 VSS 2.24525
R864 VSS.n15 VSS.n203 2.2136
R865 VSS.n3 VSS 2.02728
R866 VSS.n1 VSS.n0 1.92998
R867 VSS.n3 VSS 1.80762
R868 VSS.n3 VSS 1.63582
R869 VSS.n3 VSS 1.40948
R870 VSS.n2 VSS.n8 1.39801
R871 VSS.n138 VSS.n25 1.37022
R872 VSS.n221 VSS.n82 1.27115
R873 VSS.n220 VSS.n82 1.27115
R874 VSS.n225 VSS.n224 1.27115
R875 VSS.n225 VSS.n9 1.27115
R876 VSS.n3 VSS.n2 1.23726
R877 VSS.n4 VSS.n2 1.02426
R878 a_6694_987.n0 a_6694_987.t0 4.91293
R879 a_6694_987.n0 a_6694_987.t2 4.89923
R880 a_6694_987.n1 a_6694_987.n0 2.6005
R881 a_6694_987.n1 a_6694_987.t3 1.41684
R882 a_6694_987.t1 a_6694_987.n1 1.41684
R883 a_5474_987.n1 a_5474_987.t2 4.89923
R884 a_5474_987.n0 a_5474_987.t3 4.77206
R885 a_5474_987.n0 a_5474_987.t0 4.14793
R886 a_5474_987.n0 a_5474_987.t4 4.14597
R887 a_5474_987.n2 a_5474_987.n1 2.6005
R888 a_5474_987.n2 a_5474_987.t5 1.41684
R889 a_5474_987.t1 a_5474_987.n2 1.41684
R890 a_5474_987.n1 a_5474_987.n0 1.02376
R891 a_4706_987.n0 a_4706_987.t0 4.91293
R892 a_4706_987.n0 a_4706_987.t2 4.89923
R893 a_4706_987.n1 a_4706_987.n0 2.6005
R894 a_4706_987.n1 a_4706_987.t3 1.41684
R895 a_4706_987.t1 a_4706_987.n1 1.41684
R896 a_3938_987.n0 a_3938_987.t0 4.91293
R897 a_3938_987.n0 a_3938_987.t3 4.89923
R898 a_3938_987.n1 a_3938_987.n0 2.6005
R899 a_3938_987.n1 a_3938_987.t2 1.41684
R900 a_3938_987.t1 a_3938_987.n1 1.41684
R901 a_2717_987.n1 a_2717_987.t4 4.89923
R902 a_2717_987.n0 a_2717_987.t5 4.77206
R903 a_2717_987.n0 a_2717_987.t0 4.14793
R904 a_2717_987.n0 a_2717_987.t2 4.14597
R905 a_2717_987.n2 a_2717_987.n1 2.6005
R906 a_2717_987.n2 a_2717_987.t3 1.41684
R907 a_2717_987.t1 a_2717_987.n2 1.41684
R908 a_2717_987.n1 a_2717_987.n0 1.02572
R909 a_1948_987.t2 a_1948_987.n1 4.91293
R910 a_1948_987.n1 a_1948_987.t1 4.89923
R911 a_1948_987.n1 a_1948_987.n0 2.6005
R912 a_1948_987.n0 a_1948_987.t0 1.41684
R913 a_1948_987.n0 a_1948_987.t3 1.41684
R914 in2.t2 in2.n21 111.456
R915 in2.n12 in2.n8 88.7005
R916 in2.n23 in2.n22 88.7005
R917 in2.n15 in2.n5 85.0505
R918 in2.t2 in2.n3 1.69161
R919 in2.n8 in2.n5 47.2505
R920 in2.n16 in2.n15 47.2505
R921 in2.n22 in2.n19 47.2505
R922 in2.n27 in2.t7 37.891
R923 in2.n27 in2.t8 19.2934
R924 in2.n2 in2.n25 5.12143
R925 in2.n9 in2.n7 17.0759
R926 in2.n12 in2.n11 15.5491
R927 in2.n25 in2.n23 15.5491
R928 in2.n18 in2.n17 11.3038
R929 in2.n13 in2.n12 11.0809
R930 in2.n23 in2.n21 11.0809
R931 in2.n18 in2.n4 10.7239
R932 in2.n16 in2.n14 10.4505
R933 in2.n0 in2.n29 10.32
R934 in2.n14 in2.n7 8.32713
R935 in2.n29 in2.n27 8.00323
R936 in2 in2.n18 7.25257
R937 in2.n17 in2.t5 6.40912
R938 in2.n26 in2.t2 6.40912
R939 in2.n0 in2.n26 6.3005
R940 in2.n14 in2.n13 5.73172
R941 in2.n29 in2.n28 5.2005
R942 in2.n9 in2.n1 5.06743
R943 in2.n13 in2.n6 3.1505
R944 in2.n15 in2.n6 3.1505
R945 in2.t5 in2.n16 3.1505
R946 in2.n21 in2.n20 3.1505
R947 in2.n19 in2.n3 87.9163
R948 in2 in2.t6 6.51843
R949 in2.t5 in2.n1 0.206238
R950 in2.t2 in2.n2 0.161734
R951 in2.t5 in2.n7 2.1221
R952 in2.n3 in2.n20 0.106663
R953 in2.n8 in2.n6 1.7505
R954 in2.n22 in2.n20 1.7505
R955 in2.n17 in2.n5 1.62981
R956 in2.n26 in2.n19 1.62981
R957 in2.n1 in2.n5 3.88957
R958 in2.n2 in2.n19 3.93332
R959 in2.t5 in2.n6 1.85912
R960 in2.n4 in2.t0 1.41684
R961 in2.n4 in2.t1 1.41684
R962 in2.n28 in2.t3 1.41684
R963 in2.n28 in2.t4 1.41684
R964 in2.n11 in2.n10 1.32827
R965 in2.n25 in2.n24 1.32827
R966 in2 in2.n0 1.28661
R967 in2.n11 in2.n9 1.16236
R968 R.n5 R.n4 149.65
R969 R.n1 R.t5 40.1505
R970 R.n10 R.t7 40.1505
R971 R.n7 R.n6 36.726
R972 R.n1 R.t6 19.2934
R973 R.n10 R.t8 19.2934
R974 R.n9 R.n1 15.8889
R975 R.n11 R.n10 15.8274
R976 R.n4 R.n3 10.0787
R977 R.n12 R.n9 9.97466
R978 R.n9 R.n8 9.80039
R979 R.n8 R.n2 8.17069
R980 R R.n0 8.08589
R981 R.n7 R.n3 5.85149
R982 R.n11 R.t4 16.0246
R983 R R.n12 8.26172
R984 R.n12 R.n11 4.5005
R985 R.n6 R.n4 4.27703
R986 R.n13 R.t2 3.35156
R987 R.n8 R.n7 2.86325
R988 R.t3 R.n5 2.42671
R989 R R.t2 12.083
R990 R.n3 R.n2 1.58769
R991 R.n0 R.t0 1.41684
R992 R.n0 R.t1 1.41684
R993 R.n5 R.n2 1.29467
R994 R.n6 R.t3 1.11195
R995 in1.t3 in1.n22 111.456
R996 in1.t2 in1.n2 1.68642
R997 in1.t2 in1.n1 0.152381
R998 in1.n24 in1.n23 88.7005
R999 in1.n8 in1.n7 85.0505
R1000 in1.n33 in1.n31 54.7505
R1001 in1.t3 in1.n5 1.69161
R1002 in1.n35 in1.n31 47.4505
R1003 in1.n11 in1.n8 47.2505
R1004 in1.n23 in1.n20 47.2505
R1005 in1.n17 in1.t7 40.1505
R1006 in1.n32 in1.t6 28.6969
R1007 in1.n19 in1.n17 28.1582
R1008 in1.n13 in1.n10 23.1801
R1009 in1.n17 in1.t8 19.2934
R1010 in1.n4 in1.n26 5.12143
R1011 in1.n12 in1.n3 16.9456
R1012 in1.n26 in1.n24 15.5491
R1013 in1.n16 in1.n15 11.2083
R1014 in1.n24 in1.n22 11.0809
R1015 in1.n16 in1.n6 10.6945
R1016 in1.n0 in1.n19 10.4576
R1017 in1.n11 in1.n9 10.4505
R1018 in1.n32 in1.n30 9.95505
R1019 in1.n31 in1.n29 8.3955
R1020 in1.n3 in1.n9 8.32713
R1021 in1 in1.n16 7.34541
R1022 in1.n37 in1.n29 6.81383
R1023 in1.n27 in1.t3 6.40912
R1024 in1.n0 in1.n27 6.3005
R1025 in1.n13 in1.n9 5.73172
R1026 in1.n33 in1.n32 5.60586
R1027 in1.n37 in1.n36 5.55593
R1028 in1.n19 in1.n18 5.2005
R1029 in1.t6 in1.n28 4.56693
R1030 in1.n36 in1.n30 4.41092
R1031 in1.n29 in1.n28 3.91121
R1032 in1.n12 in1.n1 5.38578
R1033 in1.n34 in1.n30 3.6505
R1034 in1.n36 in1.n35 3.6505
R1035 in1.n14 in1.n13 3.1505
R1036 in1.n14 in1.n8 3.1505
R1037 in1.t2 in1.n11 3.1505
R1038 in1.n22 in1.n21 3.1505
R1039 in1.n20 in1.n5 87.9163
R1040 in1.n15 in1.t2 2.93326
R1041 in1.t3 in1.n4 0.161734
R1042 in1 in1.n38 2.66717
R1043 in1.n38 in1.n28 2.2635
R1044 in1.t2 in1.n3 2.1221
R1045 in1.n34 in1.n33 1.95586
R1046 in1.n10 in1.n12 1.92498
R1047 in1.n5 in1.n21 0.106663
R1048 in1.n35 in1.n34 1.8255
R1049 in1.n1 in1.n7 3.86742
R1050 in1.n14 in1.n2 0.0332878
R1051 in1.n7 in1.n2 48.9364
R1052 in1.n23 in1.n21 1.7505
R1053 in1.n15 in1.n7 1.62981
R1054 in1.n27 in1.n20 1.62981
R1055 in1.n4 in1.n20 3.93332
R1056 in1.n18 in1.t0 1.41684
R1057 in1.n18 in1.t1 1.41684
R1058 in1.n6 in1.t4 1.41684
R1059 in1.n6 in1.t5 1.41684
R1060 in1.n26 in1.n25 1.32827
R1061 in1 in1.n0 1.32552
R1062 in1.n38 in1.n37 1.0225
C0 CLKb in1 0.84593f
C1 QN out2 0.35558f
C2 D R 0.14011f
C3 VDD SN 0.54419f
C4 SNb a_921_203r# 0.28322f
C5 CLKN RN 0.18745f
C6 D VDD 0.31795f
C7 out2 a_6795_203r# 0.22678f
C8 CLKb in2 0.75416f
C9 CLKb CLKN 1.16388f
C10 R SNb 2.59654f
C11 VDD SNb 0.94579f
C12 CLKN in1 0.52197f
C13 a_2824_203r# in1 0.17137f
C14 VDD CLK 0.50901f
C15 SN CLKb 0.27154f
C16 D CLKb 0.17911f
C17 QN VDD 0.6754f
C18 RN SNb 0.14858f
C19 CLKN in2 0.54319f
C20 out2 R 0.33041f
C21 VDD out2 0.86663f
C22 CLKb SNb 2.34667f
C23 SNb in1 0.26186f
C24 SN CLKN 0.24042f
C25 QN Q 0.32041f
C26 VDD a_921_203r# 0.53145f
C27 D CLKN 0.23048f
C28 out1 R 0.35985f
C29 in2 SNb 0.24533f
C30 VDD out1 0.66187f
C31 VDD R 1.1159f
C32 CLKN SNb 1.09473f
C33 a_5574_203r# in2 0.16711f
C34 CLK CLKN 0.29377f
C35 RN R 0.17377f
C36 a_4807_203r# out1 0.1003f
C37 VDD RN 0.40147f
C38 out2 in2 0.95538f
C39 out1 CLKb 0.35222f
C40 out2 CLKN 0.5168f
C41 CLKb R 1.0824f
C42 VDD CLKb 1.17747f
C43 VDD Q 0.33484f
C44 out1 in1 0.98196f
C45 R in1 0.26945f
C46 VDD in1 0.47169f
C47 CLKN a_921_203r# 0.14983f
C48 a_4039_203r# out1 0.21007f
C49 CLKb RN 0.10492f
C50 in2 R 0.23672f
C51 VDD in2 0.5041f
C52 SN a_921_203r# 0.25952f
C53 out1 CLKN 0.53022f
C54 CLKN R 2.00061f
C55 VDD CLKN 1.57309f
C56 D a_2065_203r# 0.10315f
C57 Q VSS 0.54506f
C58 QN VSS 1.02067f
C59 D VSS 0.86438f
C60 RN VSS 0.81335f
C61 SN VSS 0.83646f
C62 CLK VSS 0.90354f
C63 VDD VSS 22.24798f
C64 a_5574_203r# VSS 0.29095f
C65 a_4807_203r# VSS 0.34289f
C66 a_4039_203r# VSS 1.23289f
C67 a_2824_203r# VSS 0.7187f
C68 a_2065_203r# VSS 1.03285f
C69 in2 VSS 1.4124f
C70 R VSS 1.68138f
C71 SNb VSS 0.16059f
C72 in1 VSS 1.21064f
C73 in1.n0 VSS 0.35284f
C74 in1.t2 VSS 0.7037f
C75 in1.t3 VSS 0.90053f
C76 in1.n6 VSS 0.14492f
C77 in1.n16 VSS 0.56099f
C78 in1.n17 VSS 0.14118f
C79 in1.n19 VSS 0.38508f
C80 in1.n28 VSS 0.10079f
C81 in1.n32 VSS 0.14564f
C82 R.t2 VSS 0.52869f
C83 R.t1 VSS 0.13363f
C84 R.t0 VSS 0.1193f
C85 R.n0 VSS 0.34281f
C86 R.n1 VSS 0.22453f
C87 R.n6 VSS 0.27684f
C88 R.n7 VSS 0.39688f
C89 R.n8 VSS 0.24499f
C90 R.n9 VSS 0.90226f
C91 R.n10 VSS 0.21436f
C92 R.n11 VSS 0.56686f
C93 R.n12 VSS 1.76204f
C94 R.n13 VSS 0.28571f
C95 in2.n0 VSS 0.32125f
C96 in2.t2 VSS 0.12209f
C97 in2.n4 VSS 0.15338f
C98 in2.n18 VSS 0.55391f
C99 in2.n27 VSS 0.15591f
C100 in2.t4 VSS 0.11482f
C101 in2.n29 VSS 0.46787f
C102 a_1948_987.t1 VSS 0.15238f
C103 a_1948_987.t3 VSS 0.10097f
C104 a_1948_987.n1 VSS 0.43231f
C105 a_1948_987.t2 VSS 0.19926f
C106 a_2717_987.n0 VSS 0.4706f
C107 a_2717_987.t3 VSS 0.12321f
C108 a_2717_987.t4 VSS 0.25109f
C109 a_2717_987.t0 VSS 0.11933f
C110 a_2717_987.t2 VSS 0.18554f
C111 a_2717_987.t5 VSS 0.18686f
C112 a_2717_987.n1 VSS 0.27131f
C113 a_3938_987.t3 VSS 0.15625f
C114 a_3938_987.t0 VSS 0.15688f
C115 a_3938_987.n0 VSS 0.4433f
C116 a_4706_987.t2 VSS 0.22615f
C117 a_4706_987.t0 VSS 0.4881f
C118 a_4706_987.n0 VSS 0.44573f
C119 a_5474_987.n0 VSS 0.46313f
C120 a_5474_987.t5 VSS 0.12251f
C121 a_5474_987.t2 VSS 0.2489f
C122 a_5474_987.t0 VSS 0.24156f
C123 a_5474_987.t4 VSS 0.18196f
C124 a_5474_987.t3 VSS 0.18421f
C125 a_5474_987.n1 VSS 0.26718f
C126 a_6694_987.t2 VSS 0.15758f
C127 a_6694_987.t0 VSS 0.21169f
C128 a_6694_987.n0 VSS 0.44706f
C129 a_6694_987.n1 VSS 0.10027f
C130 VSS.t29 VSS 0.13751f
C131 VSS.t9 VSS 0.50454f
C132 VSS.t21 VSS 0.2806f
C133 VSS.t19 VSS 0.50726f
C134 VSS.t3 VSS 0.48385f
C135 VSS.t35 VSS 0.10396f
C136 VSS.t25 VSS 0.18962f
C137 VSS.t11 VSS 0.16879f
C138 VSS.t15 VSS 0.2481f
C139 VSS.t23 VSS 0.27658f
C140 VSS.t27 VSS 0.13807f
C141 VSS.t13 VSS 0.22839f
C142 VDD.n0 VSS 0.50877f
C143 VDD.n1 VSS 0.32664f
C144 VDD.n4 VSS 0.18748f
C145 VDD.n5 VSS 0.18194f
C146 VDD.n7 VSS 0.26966f
C147 VDD.n56 VSS 0.12932f
C148 VDD.n69 VSS 0.11662f
C149 VDD.t7 VSS 0.13349f
C150 VDD.n73 VSS 0.10738f
C151 VDD.n77 VSS 0.10738f
C152 VDD.t38 VSS 0.3398f
C153 VDD.n92 VSS 0.12932f
C154 VDD.n95 VSS 0.12932f
C155 VDD.t32 VSS 0.17003f
C156 VDD.n110 VSS 0.11084f
C157 VDD.n120 VSS 0.12008f
C158 VDD.t31 VSS 0.12932f
C159 VDD.n132 VSS 0.12932f
C160 VDD.n154 VSS 0.12932f
C161 VDD.n163 VSS 0.12932f
C162 VDD.n172 VSS 0.12354f
C163 VDD.n177 VSS 0.12585f
C164 VDD.n184 VSS 0.11431f
C165 VDD.n193 VSS 0.12354f
C166 VDD.n194 VSS 0.10738f
C167 VDD.n203 VSS 0.24247f
C168 VDD.n204 VSS 0.26633f
C169 VDD.n205 VSS 0.26633f
C170 VDD.n206 VSS 0.16858f
C171 VDD.n207 VSS 0.12008f
C172 SN.n0 VSS 0.13638f
C173 RN.n0 VSS 0.17559f
C174 D.n0 VSS 0.23542f
C175 QN.t1 VSS 0.51519f
C176 QN.n6 VSS 0.11233f
C177 Q.t1 VSS 0.14852f
.ends
