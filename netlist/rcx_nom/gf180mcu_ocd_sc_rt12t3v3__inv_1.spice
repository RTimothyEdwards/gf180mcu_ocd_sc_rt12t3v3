* NGSPICE file created from gf180mcu_ocd_sc_rt12t3v3__inv_1.ext - technology: gf180mcuD

.subckt gf180mcu_ocd_sc_rt12t3v3__inv_1 A Y VDD VSS
X0 VDD.t3 A.t1 Y.t0 VDD.t2 pfet_03v3 ad=2.7424p pd=12.83u as=0.3341p ps=1.805u w=1.285u l=0.28u
X1 Y.t2 A.t2 VDD.t1 VDD.t0 pfet_03v3 ad=0.3341p pd=1.805u as=2.7424p ps=12.83u w=1.285u l=0.28u
X2 Y.t1 A.t0 VSS.t1 VSS.t0 nfet_03v3 ad=0.3087p pd=2.01u as=4.22095p ps=23.13u w=1.02u l=0.28u
R0 Y.n6 Y.t1 50.9005
R1 Y.n2 Y.n7 32.5888
R2 Y.n7 Y.n6 16.9387
R3 Y.n6 Y.n0 11.9058
R4 Y Y.n3 6.5705
R5 Y.n3 Y.n0 3.31861
R6 Y.n7 Y.n4 3.6505
R7 Y Y.n5 2.98876
R8 Y.n2 Y.n0 0.0474974
R9 Y.n1 Y.t1 0.459182
R10 Y.n1 Y.n4 0.825727
R11 Y.n5 Y.t2 1.41684
R12 Y.n5 Y.t0 1.41684
R13 Y.n3 Y.t1 5.88322
R14 Y.n3 Y.n4 1.7588
R15 Y.n2 Y.n1 1.57306
R16 A.n0 A.t1 40.1505
R17 A.n0 A.t2 19.2934
R18 A A.n0 10.0207
R19 A A.t0 6.98791
R20 VDD.n28 VDD.n14 137.088
R21 VDD.n24 VDD.n23 137.088
R22 VDD.n22 VDD.n0 137.088
R23 VDD.t0 VDD.n14 117.504
R24 VDD.t2 VDD.n22 97.9197
R25 VDD.n19 VDD.n15 74.5982
R26 VDD.n23 VDD.t2 39.1682
R27 VDD.n24 VDD.t0 19.5843
R28 VDD.n29 VDD.n13 9.8005
R29 VDD.n25 VDD.n11 2.75725
R30 VDD.n25 VDD.n17 9.8005
R31 VDD.n21 VDD.n17 9.8005
R32 VDD.n10 VDD.n20 4.85219
R33 VDD.n8 VDD.n18 5.40705
R34 VDD VDD.n19 6.51963
R35 VDD.n29 VDD.n28 6.3005
R36 VDD VDD.n29 6.3005
R37 VDD.n14 VDD.n13 6.3005
R38 VDD.n13 VDD.n11 2.75725
R39 VDD.n25 VDD.n24 6.3005
R40 VDD VDD.n11 1.77287
R41 VDD.n23 VDD.n17 6.3005
R42 VDD.n17 VDD 6.3005
R43 VDD.n22 VDD.n21 6.3005
R44 VDD.n21 VDD.n10 2.75725
R45 VDD VDD.n10 1.77287
R46 VDD.n12 VDD 6.3005
R47 VDD.n6 VDD.n7 1.85802
R48 VDD.n9 VDD.n7 2.22249
R49 VDD.n28 VDD.n15 6.3005
R50 VDD VDD.n8 1.82635
R51 VDD.n1 VDD.n0 2.13272
R52 VDD.n4 VDD.n1 2.03756
R53 VDD.n4 VDD.n2 2.101
R54 VDD VDD.n2 2.101
R55 VDD.n20 VDD.n2 4.19594
R56 VDD.n29 VDD.n12 6.19113
R57 VDD.n1 VDD.n8 4.68735
R58 VDD.n26 VDD.n16 5.35538
R59 VDD.n16 VDD.n7 4.48286
R60 VDD.n5 VDD 2.91159
R61 VDD VDD.n3 2.90963
R62 VDD.n26 VDD.n15 2.82549
R63 VDD.n19 VDD.n18 2.75725
R64 VDD.n28 VDD.n27 2.1923
R65 VDD.n20 VDD.n0 2.10378
R66 VDD.n9 VDD.n26 2.03587
R67 VDD.n27 VDD.n12 1.91839
R68 VDD.n27 VDD.n6 1.91839
R69 VDD.n28 VDD.n16 1.83883
R70 VDD.n18 VDD.n0 1.77287
R71 VDD.n9 VDD 1.71963
R72 VDD.n5 VDD.t1 1.41684
R73 VDD.n3 VDD.t3 1.41684
R74 VDD.n4 VDD.n3 1.26229
R75 VDD.n6 VDD.n5 1.22714
R76 VSS.n15 VSS.n12 452.993
R77 VSS.n23 VSS.n8 452.736
R78 VSS.n18 VSS.n12 452.736
R79 VSS.t0 VSS.n8 254.665
R80 VSS.n18 VSS.t0 198.072
R81 VSS.n17 VSS.n5 10.8894
R82 VSS.n17 VSS.n13 10.8894
R83 VSS.n1 VSS.n19 2.66071
R84 VSS.n19 VSS.n11 10.8894
R85 VSS.n22 VSS.n6 10.4384
R86 VSS.n25 VSS.n2 9.76841
R87 VSS.n16 VSS.n15 7.43544
R88 VSS.n15 VSS.n14 7.43544
R89 VSS.n5 VSS.n7 7.38939
R90 VSS.n21 VSS.n20 7.38939
R91 VSS.n22 VSS.n4 2.35671
R92 VSS VSS.n25 5.2005
R93 VSS.n7 VSS 5.2005
R94 VSS.n23 VSS.n22 5.2005
R95 VSS.n4 VSS 1.074
R96 VSS.n23 VSS.n2 5.2005
R97 VSS.n2 VSS 5.2005
R98 VSS VSS.n21 5.2005
R99 VSS VSS.n6 5.2005
R100 VSS.n12 VSS.n11 5.2005
R101 VSS.n19 VSS.n18 5.2005
R102 VSS.n1 VSS.n0 1.27115
R103 VSS.n20 VSS.n8 5.2005
R104 VSS.n20 VSS.n1 2.66071
R105 VSS.n5 VSS.n8 5.2005
R106 VSS VSS.n5 5.2005
R107 VSS.n18 VSS.n17 5.2005
R108 VSS.n17 VSS 5.2005
R109 VSS.n13 VSS.n12 5.2005
R110 VSS.n3 VSS.t1 4.4105
R111 VSS.n4 VSS.n3 1.42802
R112 VSS.n3 VSS.n10 2.7725
R113 VSS.n3 VSS.n2 2.71962
R114 VSS.n24 VSS.n7 2.66071
R115 VSS.n6 VSS.n9 2.66071
R116 VSS.n21 VSS.n9 2.66071
R117 VSS.n25 VSS.n24 2.66071
R118 VSS.n14 VSS.n11 2.63361
R119 VSS.n16 VSS.n13 2.63361
R120 VSS VSS.n16 1.53032
R121 VSS.n14 VSS.n0 1.53032
R122 VSS.n24 VSS.n23 1.27115
R123 VSS.n23 VSS.n9 1.27115
R124 VSS VSS.n0 1.00862
C0 Y VDD 0.31136f
C1 Y A 0.30381f
C2 A VDD 0.41202f
C3 Y VSS 0.5366f
C4 A VSS 0.89832f
C5 VDD VSS 2.30029f
C6 VSS.t1 VSS 0.12106f
C7 VDD.n0 VSS 0.10282f
C8 VDD.n28 VSS 0.10282f
C9 Y.t1 VSS 0.13137f
.ends
