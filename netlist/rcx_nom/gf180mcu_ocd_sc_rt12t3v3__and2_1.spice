* NGSPICE file created from gf180mcu_ocd_sc_rt12t3v3__and2_1.ext - technology: gf180mcuD

.subckt gf180mcu_ocd_sc_rt12t3v3__and2_1 A B Y VDD VSS
X0 a_236_987.t4 A.t0 a_193_203r# VSS.t4 nfet_03v3 ad=0.3087p pd=2.015u as=0.52065p ps=3.23u w=1.02u l=0.28u
X1 VDD.t3 B.t1 a_236_987.t1 VDD.t2 pfet_03v3 ad=0.3341p pd=1.805u as=0.3341p ps=1.805u w=1.285u l=0.28u
X2 Y.t2 a_236_987.t7 VDD.t7 VDD.t6 pfet_03v3 ad=0.3341p pd=1.805u as=0.3341p ps=1.805u w=1.285u l=0.28u
X3 VDD.t5 a_236_987.t6 Y.t0 VDD.t4 pfet_03v3 ad=0.5654p pd=3.45u as=0.3341p ps=1.805u w=1.285u l=0.28u
X4 a_236_987.t2 A.t2 VDD.t9 VDD.t8 pfet_03v3 ad=0.3341p pd=1.805u as=0.3341p ps=1.805u w=1.285u l=0.28u
X5 a_236_987.t0 B.t2 VDD.t1 VDD.t0 pfet_03v3 ad=0.3341p pd=1.805u as=0.5654p ps=3.45u w=1.285u l=0.28u
X6 VDD.t11 A.t1 a_236_987.t3 VDD.t10 pfet_03v3 ad=0.3341p pd=1.805u as=0.3341p ps=1.805u w=1.285u l=0.28u
X7 a_193_203r# B.t0 VSS.t1 VSS.t0 nfet_03v3 ad=0.3087p pd=2.01u as=3.40955p ps=18.84u w=1.02u l=0.28u
X8 Y.t1 a_236_987.t5 VSS.t3 VSS.t2 nfet_03v3 ad=0.3087p pd=2.01u as=3.40955p ps=18.84u w=1.02u l=0.28u
R0 Y.n6 Y.t1 50.9005
R1 Y.n2 Y.n7 32.5888
R2 Y.n7 Y.n6 16.9387
R3 Y.n6 Y.n0 11.9058
R4 Y Y.n3 6.39761
R5 Y.n3 Y.n0 3.31861
R6 Y.n7 Y.n4 3.6505
R7 Y Y.n5 2.98579
R8 Y.n2 Y.n0 0.0474974
R9 Y.n1 Y.t1 0.459182
R10 Y.n1 Y.n4 0.825727
R11 Y.n5 Y.t2 1.41684
R12 Y.n5 Y.t0 1.41684
R13 Y.n3 Y.t1 5.88322
R14 Y.n3 Y.n4 1.7588
R15 Y.n2 Y.n1 1.57306
R16 A.n0 A.t1 40.1505
R17 A.n0 A.t2 19.2934
R18 A A.n0 9.82344
R19 A.t0 A 9.47739
R20 B.n0 B.t1 40.1505
R21 B.n0 B.t2 19.2934
R22 B B.n0 10.0207
R23 B B.t0 8.89733
R24 VDD.n39 VDD.n38 170.816
R25 VDD.n41 VDD.n40 137.088
R26 VDD.n25 VDD.n24 137.088
R27 VDD.n29 VDD.n20 137.088
R28 VDD.n31 VDD.t4 137.088
R29 VDD.t4 VDD.n16 137.088
R30 VDD.n37 VDD.n16 137.088
R31 VDD.n41 VDD.t0 117.504
R32 VDD.n30 VDD.t10 117.504
R33 VDD.n26 VDD.t2 97.9197
R34 VDD.n26 VDD.t8 97.9197
R35 VDD.t6 VDD.n30 78.3359
R36 VDD.n31 VDD.t6 58.752
R37 VDD.t2 VDD.n25 39.1682
R38 VDD.t8 VDD.n20 39.1682
R39 VDD.n24 VDD.t0 19.5843
R40 VDD.t10 VDD.n29 19.5843
R41 VDD.n35 VDD.n34 9.8005
R42 VDD.n43 VDD.n42 9.8005
R43 VDD.n42 VDD.n7 2.75725
R44 VDD.n23 VDD.n10 9.8005
R45 VDD.n27 VDD.n23 9.8005
R46 VDD.n5 VDD.n4 2.75725
R47 VDD.n28 VDD.n4 9.8005
R48 VDD.n6 VDD.n19 2.75725
R49 VDD.n32 VDD.n19 9.8005
R50 VDD.n32 VDD.n18 9.8005
R51 VDD.n8 VDD.n18 2.75725
R52 VDD.n36 VDD.n33 9.8005
R53 VDD.n13 VDD.n12 9.8005
R54 VDD.n2 VDD.n9 4.93411
R55 VDD.n3 VDD.n17 4.93411
R56 VDD VDD.n43 6.3005
R57 VDD.n42 VDD.n41 6.3005
R58 VDD.n7 VDD 1.77287
R59 VDD.n24 VDD.n10 6.3005
R60 VDD.n7 VDD.n10 2.75725
R61 VDD.n25 VDD.n23 6.3005
R62 VDD.n23 VDD 6.3005
R63 VDD.n27 VDD.n26 6.3005
R64 VDD.n5 VDD.n27 2.75725
R65 VDD.n4 VDD.n20 6.3005
R66 VDD VDD.n5 1.77287
R67 VDD.n29 VDD.n28 6.3005
R68 VDD.n28 VDD.n6 2.75725
R69 VDD.n30 VDD.n19 6.3005
R70 VDD.n6 VDD 1.77287
R71 VDD.n32 VDD.n31 6.3005
R72 VDD VDD.n32 6.3005
R73 VDD.t4 VDD.n18 6.3005
R74 VDD VDD.n8 1.77287
R75 VDD.n33 VDD.n16 6.3005
R76 VDD.n33 VDD.n8 2.75725
R77 VDD.n37 VDD.n36 6.3005
R78 VDD.n36 VDD.n3 2.17736
R79 VDD.n38 VDD.n37 6.3005
R80 VDD.n34 VDD 6.3005
R81 VDD VDD.n35 6.3005
R82 VDD.n3 VDD 2.06282
R83 VDD.n2 VDD.n1 1.77287
R84 VDD.n1 VDD.n13 6.3005
R85 VDD.n40 VDD.n12 6.3005
R86 VDD.n40 VDD.n39 6.3005
R87 VDD.n15 VDD.n0 5.4873
R88 VDD VDD.n22 5.42159
R89 VDD VDD.t1 4.32793
R90 VDD VDD.t5 4.32597
R91 VDD VDD.n21 2.91159
R92 VDD.n38 VDD.n0 2.82549
R93 VDD.n39 VDD.n14 2.82549
R94 VDD.n34 VDD.n15 2.75725
R95 VDD.n35 VDD.n17 2.75725
R96 VDD.n13 VDD.n11 2.75725
R97 VDD.n2 VDD.n11 5.514
R98 VDD.n14 VDD.n12 2.73055
R99 VDD.n43 VDD.n9 2.17736
R100 VDD.n40 VDD.n9 2.06282
R101 VDD VDD.n0 2.03587
R102 VDD.n14 VDD.n1 2.03587
R103 VDD VDD.n1 2.0045
R104 VDD.n37 VDD.n15 1.77287
R105 VDD.n37 VDD.n17 1.77287
R106 VDD.n40 VDD.n11 1.77287
R107 VDD.n21 VDD.t11 1.41684
R108 VDD.n21 VDD.t7 1.41684
R109 VDD.n22 VDD.t3 1.41684
R110 VDD.n22 VDD.t9 1.41684
R111 VSS.n40 VSS.n39 513.399
R112 VSS.n25 VSS.n22 513.399
R113 VSS.n26 VSS.n25 513.399
R114 VSS.n27 VSS.n26 513.399
R115 VSS.n30 VSS.n20 513.399
R116 VSS.n31 VSS.n30 513.399
R117 VSS.n32 VSS.n19 513.399
R118 VSS.n19 VSS.n16 513.399
R119 VSS.t4 VSS.n20 467.56
R120 VSS.n40 VSS.t0 316.291
R121 VSS.n32 VSS.t2 316.291
R122 VSS.n37 VSS.n36 202.63
R123 VSS.n22 VSS.t0 197.109
R124 VSS.t2 VSS.n31 197.109
R125 VSS.n27 VSS.t4 45.8397
R126 VSS.n28 VSS.n21 10.8894
R127 VSS.n11 VSS.n10 2.66071
R128 VSS.n29 VSS.n10 10.8894
R129 VSS.n41 VSS.n15 10.8894
R130 VSS.n12 VSS.n14 2.65917
R131 VSS.n5 VSS.n13 2.64679
R132 VSS.n24 VSS.n21 10.4384
R133 VSS.n41 VSS.n6 9.76841
R134 VSS.n1 VSS.n14 9.44628
R135 VSS.n1 VSS.n5 9.10893
R136 VSS.n9 VSS.n15 7.38939
R137 VSS.n33 VSS.n17 7.38939
R138 VSS.n24 VSS.n8 2.35671
R139 VSS VSS.n37 5.41963
R140 VSS.n36 VSS.n0 5.41963
R141 VSS.n41 VSS.n40 5.2005
R142 VSS VSS.n41 5.2005
R143 VSS.n39 VSS.n15 5.2005
R144 VSS.n15 VSS 5.2005
R145 VSS.n25 VSS.n24 5.2005
R146 VSS.n22 VSS.n6 5.2005
R147 VSS.n6 VSS 5.2005
R148 VSS.n31 VSS.n14 5.2005
R149 VSS VSS.n12 1.27192
R150 VSS.n30 VSS.n29 5.2005
R151 VSS.n29 VSS.n12 2.65917
R152 VSS.n10 VSS.n20 5.2005
R153 VSS VSS.n11 1.27115
R154 VSS.n28 VSS.n27 5.2005
R155 VSS.n11 VSS.n28 2.66071
R156 VSS.n26 VSS.n21 5.2005
R157 VSS.n21 VSS 5.2005
R158 VSS.n1 VSS.n32 5.2005
R159 VSS.n17 VSS.n16 5.2005
R160 VSS.n13 VSS.n17 2.64679
R161 VSS.n19 VSS.n5 5.2005
R162 VSS VSS.n13 1.2781
R163 VSS.n4 VSS.n0 1.27115
R164 VSS.n34 VSS.n4 5.32092
R165 VSS.n33 VSS 5.2005
R166 VSS VSS.n9 5.2005
R167 VSS VSS.n3 1.27115
R168 VSS.n1 VSS.t3 4.4105
R169 VSS.n7 VSS.t1 4.4105
R170 VSS.n8 VSS.n7 1.42802
R171 VSS.n1 VSS.n18 2.7725
R172 VSS.n7 VSS.n23 2.7725
R173 VSS.n7 VSS.n6 2.71962
R174 VSS.n37 VSS.n2 2.66071
R175 VSS.n36 VSS.n35 2.66071
R176 VSS.n38 VSS.n9 2.66071
R177 VSS.n38 VSS.n3 5.32092
R178 VSS.n3 VSS.n2 5.32092
R179 VSS.n34 VSS.n33 2.66071
R180 VSS.n35 VSS.n4 5.32092
R181 VSS.n1 VSS 2.34249
R182 VSS.n35 VSS.n16 1.27115
R183 VSS.n34 VSS.n16 1.27115
R184 VSS.n39 VSS.n38 1.27115
R185 VSS.n39 VSS.n2 1.27115
R186 VSS VSS.n0 1.19582
R187 VSS.n8 VSS 1.074
R188 a_236_987.t4 a_236_987.n2 1.6599
R189 a_236_987.n10 a_236_987.t6 40.1505
R190 a_236_987.n8 a_236_987.n2 31.4289
R191 a_236_987.n10 a_236_987.t7 19.2934
R192 a_236_987.n6 a_236_987.n5 16.6035
R193 a_236_987.n0 a_236_987.t5 16.0267
R194 a_236_987.n1 a_236_987.n10 9.56479
R195 a_236_987.n0 a_236_987.n9 6.74273
R196 a_236_987.n2 a_236_987.n6 3.68665
R197 a_236_987.n11 a_236_987.n1 3.3518
R198 a_236_987.n8 a_236_987.n7 3.04188
R199 a_236_987.n1 a_236_987.n4 2.72963
R200 a_236_987.n7 a_236_987.n5 1.76263
R201 a_236_987.n9 a_236_987.n8 1.62981
R202 a_236_987.n7 a_236_987.t4 1.62981
R203 a_236_987.n1 a_236_987.n0 1.4405
R204 a_236_987.n11 a_236_987.t0 1.41684
R205 a_236_987.t1 a_236_987.n11 1.41684
R206 a_236_987.n4 a_236_987.t2 1.41684
R207 a_236_987.n4 a_236_987.t3 1.41684
R208 a_236_987.t4 a_236_987.n3 1.28915
R209 a_236_987.n5 a_236_987.n3 1.18357
R210 a_236_987.n9 a_236_987.n3 1.18053
C0 VDD B 0.40499f
C1 VDD Y 0.3215f
C2 A VDD 0.34663f
C3 Y VSS 0.48933f
C4 A VSS 0.76239f
C5 B VSS 0.81634f
C6 VDD VSS 4.16055f
C7 a_193_203r# VSS 0.36935f
C8 a_236_987.n0 VSS 0.35701f
C9 a_236_987.n1 VSS 0.24938f
C10 a_236_987.t4 VSS 0.18123f
C11 VSS.t1 VSS 0.11084f
C12 VSS.t3 VSS 0.10541f
C13 VDD.n37 VSS 0.14779f
C14 VDD.n40 VSS 0.14779f
C15 Y.t1 VSS 0.11559f
.ends
