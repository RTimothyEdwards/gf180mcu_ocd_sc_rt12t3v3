* NGSPICE file created from gf180mcu_ocd_sc_rt12t3v3__buf_1.ext - technology: gf180mcuD

.subckt gf180mcu_ocd_sc_rt12t3v3__buf_1 A Y VDD VSS
X0 VDD.t7 A.t1 a_193_203r# VDD.t6 pfet_03v3 ad=0.3341p pd=1.805u as=0.3341p ps=1.805u w=1.285u l=0.28u
X1 Y.t1 a_193_203r# VSS.t1 VSS.t0 nfet_03v3 ad=0.3087p pd=2.01u as=2.92382p ps=15.475u w=1.02u l=0.28u
X2 Y.t0 a_193_203r# VDD.t1 VDD.t0 pfet_03v3 ad=0.3341p pd=1.805u as=0.3341p ps=1.805u w=1.285u l=0.28u
X3 a_193_203r# A.t2 VDD.t5 VDD.t4 pfet_03v3 ad=0.3341p pd=1.805u as=0.5654p ps=3.45u w=1.285u l=0.28u
X4 VDD.t3 a_193_203r# Y.t2 VDD.t2 pfet_03v3 ad=0.5654p pd=3.45u as=0.3341p ps=1.805u w=1.285u l=0.28u
X5 a_193_203r# A.t0 VSS.t3 VSS.t2 nfet_03v3 ad=0.3087p pd=2.01u as=2.92382p ps=15.475u w=1.02u l=0.28u
R0 Y.n6 Y.t1 50.9005
R1 Y.n2 Y.n7 32.5888
R2 Y.n7 Y.n6 16.9387
R3 Y.n6 Y.n0 11.9058
R4 Y Y.n3 6.51165
R5 Y.n3 Y.n0 3.31861
R6 Y.n7 Y.n4 3.6505
R7 Y Y.n5 2.98717
R8 Y.n2 Y.n0 0.0474974
R9 Y.n1 Y.t1 0.459182
R10 Y.n1 Y.n4 0.825727
R11 Y.n5 Y.t0 1.41684
R12 Y.n5 Y.t2 1.41684
R13 Y.n3 Y.t1 5.88322
R14 Y.n3 Y.n4 1.7588
R15 Y.n2 Y.n1 1.57306
R16 A.n0 A.t1 40.1505
R17 A.n0 A.t2 19.2934
R18 A A.n0 10.0207
R19 A A.t0 7.28459
R20 VDD.n34 VDD.n33 137.088
R21 VDD.n24 VDD.n22 137.088
R22 VDD.n26 VDD.n21 137.088
R23 VDD.n30 VDD.n16 137.088
R24 VDD.n32 VDD.n31 122.707
R25 VDD.n34 VDD.t4 117.504
R26 VDD.t2 VDD.n16 117.504
R27 VDD.n25 VDD.t6 97.9197
R28 VDD.t0 VDD.n25 97.9197
R29 VDD.t6 VDD.n24 39.1682
R30 VDD.n26 VDD.t0 39.1682
R31 VDD.n22 VDD.t4 19.5843
R32 VDD.n21 VDD.t2 19.5843
R33 VDD.n36 VDD.n35 9.8005
R34 VDD.n35 VDD.n6 2.75725
R35 VDD.n23 VDD.n8 9.8005
R36 VDD.n4 VDD.n20 2.75725
R37 VDD.n27 VDD.n20 9.8005
R38 VDD.n27 VDD.n18 9.8005
R39 VDD.n5 VDD.n18 2.75725
R40 VDD.n29 VDD.n28 9.8005
R41 VDD.n13 VDD.n10 9.8005
R42 VDD.n12 VDD.n11 9.8005
R43 VDD.n3 VDD.n17 4.93411
R44 VDD VDD.n36 6.3005
R45 VDD.n35 VDD.n34 6.3005
R46 VDD.n6 VDD 1.77287
R47 VDD.n22 VDD.n8 6.3005
R48 VDD.n6 VDD.n8 2.75725
R49 VDD.n24 VDD.n23 6.3005
R50 VDD.n23 VDD.n4 2.75725
R51 VDD.n25 VDD.n20 6.3005
R52 VDD.n4 VDD.n1 1.77287
R53 VDD.n27 VDD.n26 6.3005
R54 VDD.n1 VDD.n27 6.3005
R55 VDD.n21 VDD.n18 6.3005
R56 VDD.n1 VDD.n5 1.77287
R57 VDD.n28 VDD.n16 6.3005
R58 VDD.n28 VDD.n5 2.75725
R59 VDD.n30 VDD.n29 6.3005
R60 VDD.n29 VDD.n3 2.17736
R61 VDD.n31 VDD.n30 6.3005
R62 VDD.n1 VDD.n2 1.77287
R63 VDD.n3 VDD.n1 2.06282
R64 VDD.n11 VDD 6.3005
R65 VDD VDD.n12 6.3005
R66 VDD VDD.n13 6.3005
R67 VDD.n33 VDD.n10 6.3005
R68 VDD.n33 VDD.n32 6.3005
R69 VDD.n15 VDD.n0 5.4873
R70 VDD VDD.t5 4.32793
R71 VDD.n1 VDD.t3 4.32597
R72 VDD.n1 VDD.n19 2.91159
R73 VDD.n31 VDD.n0 2.82549
R74 VDD.n32 VDD.n14 2.82549
R75 VDD.n2 VDD.n15 5.514
R76 VDD.n2 VDD.n17 5.514
R77 VDD.n13 VDD.n9 2.75725
R78 VDD.n12 VDD.n9 2.75725
R79 VDD.n14 VDD.n10 2.73055
R80 VDD.n11 VDD.n7 2.17736
R81 VDD.n36 VDD.n7 2.17736
R82 VDD.n33 VDD.n7 2.06282
R83 VDD.n1 VDD.n0 2.03587
R84 VDD.n14 VDD 2.03587
R85 VDD.n30 VDD.n15 1.77287
R86 VDD.n30 VDD.n17 1.77287
R87 VDD.n33 VDD.n9 1.77287
R88 VDD.n1 VDD 1.7525
R89 VDD.n19 VDD.t7 1.41684
R90 VDD.n19 VDD.t1 1.41684
R91 VSS.n34 VSS.n33 513.399
R92 VSS.n20 VSS.n19 513.399
R93 VSS.n20 VSS.n18 513.399
R94 VSS.n24 VSS.n23 513.399
R95 VSS.n25 VSS.n24 513.399
R96 VSS.n25 VSS.n14 513.399
R97 VSS.n18 VSS.t0 472.144
R98 VSS.n34 VSS.t2 316.291
R99 VSS.n19 VSS.t2 197.109
R100 VSS.n31 VSS.n30 149.174
R101 VSS.n23 VSS.t0 41.2558
R102 VSS.n35 VSS.n13 10.8894
R103 VSS.n10 VSS.n9 2.64278
R104 VSS.n21 VSS.n16 10.4384
R105 VSS.n11 VSS.n16 2.57652
R106 VSS.n26 VSS.n12 9.94306
R107 VSS.n35 VSS.n6 9.76841
R108 VSS.n8 VSS.n13 7.38939
R109 VSS.n27 VSS.n9 7.29217
R110 VSS.n21 VSS.n5 2.35671
R111 VSS VSS.n31 5.41963
R112 VSS.n30 VSS 5.41963
R113 VSS.n22 VSS.n3 5.39809
R114 VSS.n35 VSS.n34 5.2005
R115 VSS VSS.n35 5.2005
R116 VSS.n33 VSS.n13 5.2005
R117 VSS.n13 VSS 5.2005
R118 VSS.n21 VSS.n20 5.2005
R119 VSS VSS.n5 1.074
R120 VSS.n19 VSS.n6 5.2005
R121 VSS.n6 VSS 5.2005
R122 VSS.n18 VSS.n16 5.2005
R123 VSS VSS.n11 1.31324
R124 VSS.n24 VSS.n12 5.2005
R125 VSS VSS.n4 1.32216
R126 VSS.n23 VSS.n22 5.2005
R127 VSS.n22 VSS.n11 2.57652
R128 VSS.n9 VSS.n14 5.2005
R129 VSS VSS.n10 1.28011
R130 VSS.n26 VSS.n25 5.2005
R131 VSS.n10 VSS.n26 2.64278
R132 VSS.n2 VSS 1.27115
R133 VSS.n28 VSS.n2 5.32092
R134 VSS.n27 VSS 5.2005
R135 VSS VSS.n8 5.2005
R136 VSS VSS.n1 1.27115
R137 VSS.n3 VSS.t1 4.4105
R138 VSS.n7 VSS.t3 4.4105
R139 VSS.n4 VSS.n12 1.69888
R140 VSS.n7 VSS.n5 1.42802
R141 VSS.n4 VSS.n3 1.02952
R142 VSS.n3 VSS.n15 2.9615
R143 VSS.n7 VSS.n17 2.7725
R144 VSS.n7 VSS.n6 2.71962
R145 VSS.n31 VSS.n0 2.66071
R146 VSS.n30 VSS.n29 2.66071
R147 VSS.n32 VSS.n8 2.66071
R148 VSS.n32 VSS.n1 5.32092
R149 VSS.n1 VSS.n0 5.32092
R150 VSS.n28 VSS.n27 2.66071
R151 VSS.n29 VSS.n2 5.32092
R152 VSS.n29 VSS.n14 1.27115
R153 VSS.n28 VSS.n14 1.27115
R154 VSS.n33 VSS.n32 1.27115
R155 VSS.n33 VSS.n0 1.27115
C0 VDD a_193_203r# 0.55553f
C1 A VDD 0.40415f
C2 Y VDD 0.3165f
C3 A a_193_203r# 0.30183f
C4 Y a_193_203r# 0.29092f
C5 Y VSS 0.50885f
C6 A VSS 0.84233f
C7 VDD VSS 3.15714f
C8 a_193_203r# VSS 0.11869f
C9 VSS.t1 VSS 0.27993f
C10 VSS.t3 VSS 0.11869f
C11 VDD.n1 VSS 0.11776f
C12 VDD.n30 VSS 0.13298f
C13 VDD.n33 VSS 0.13672f
C14 Y.t1 VSS 0.29018f
.ends
